ADE simulation setup
Run mode: Single Run, Sweeps and Corners
Tests:
  INV_HV:inv_hv_tb:1: INV_HV/inv_hv_tb/schematic, simulator spectre
