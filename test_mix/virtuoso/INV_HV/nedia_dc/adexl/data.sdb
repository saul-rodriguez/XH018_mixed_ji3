ADE simulation setup
Run mode: Single Run, Sweeps and Corners
Tests:
  INV_HV:nedia_dc:1: INV_HV/nedia_dc/schematic, simulator spectre
Global variables:
  VDS = 1
  VGS = 0:1:18
