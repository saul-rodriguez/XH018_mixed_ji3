ADE simulation setup
Run mode: Single Run, Sweeps and Corners
Tests:
  CHARACTERIZATION:FT_3:1: CHARACTERIZATION/FT_3/schematic, simulator spectre
Global variables:
  IDS = {From/To}Decade:1u:10:1m{From/To}
  L = 0.35u
  NF = 1
  VDS = 1
  WF = 10u
