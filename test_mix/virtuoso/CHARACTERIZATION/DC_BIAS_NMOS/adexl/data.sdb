ADE simulation setup
Run mode: Single Run, Sweeps and Corners
Tests:
  CHARACTERIZATION:DC_BIAS_NMOS:VGS: CHARACTERIZATION/DC_BIAS_NMOS/schematic, simulator spectre
    Outputs: gm
  CHARACTERIZATION:DC_BIAS_NMOS:VDS: CHARACTERIZATION/DC_BIAS_NMOS/schematic, simulator spectre
    Outputs: gm
Global variables:
  VDS = 0:0.1:1.8
  VGS = 1
