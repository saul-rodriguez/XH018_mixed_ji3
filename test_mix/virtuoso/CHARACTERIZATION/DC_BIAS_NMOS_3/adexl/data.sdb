ADE simulation setup
Run mode: Single Run, Sweeps and Corners
Tests:
  CHARACTERIZATION:DC_BIAS_NMOS_L:1: CHARACTERIZATION/DC_BIAS_NMOS_3/schematic, simulator spectre
Global variables:
  L1 = 1u
  NF1 = 1
  VDS = 1
  VGS = 0:0.05:3.3
  WF1 = 10u
