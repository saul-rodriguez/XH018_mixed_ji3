ADE simulation setup
Run mode: Single Run, Sweeps and Corners
Tests:
  CHARACTERIZATION:DC_BIAS_NMOS_L:1: CHARACTERIZATION/DC_BIAS_NMOS_L/schematic, simulator spectre
Global variables:
  L1 = 1u
  NF1 = 1
  VDS = 0:0.05:1.8
  VGS = 1
  WF1 = 10u
