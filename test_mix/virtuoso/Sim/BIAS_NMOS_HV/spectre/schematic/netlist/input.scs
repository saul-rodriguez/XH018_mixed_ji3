// Design: CHARACTERIZATION/BIAS_NMOS_HV
simulator lang=spectre
global 0
parameters IDS=0.05 VDS=5.0 WF=0.0001 NF=8
include "/home/saul/pkg/xfab/XKIT/xh018/cadence/v9_0/spectre/v9_0_2/lpmos/config.scs" section=default
include "/home/saul/pkg/xfab/XKIT/xh018/cadence/v9_0/spectre/v9_0_2/lpmos/param.scs" section=3s
include "/home/saul/pkg/xfab/XKIT/xh018/cadence/v9_0/spectre/v9_0_2/lpmos/bip.scs" section=tm
include "/home/saul/pkg/xfab/XKIT/xh018/cadence/v9_0/spectre/v9_0_2/lpmos/cap.scs" section=tm
include "/home/saul/pkg/xfab/XKIT/xh018/cadence/v9_0/spectre/v9_0_2/lpmos/dio.scs" section=tm
include "/home/saul/pkg/xfab/XKIT/xh018/cadence/v9_0/spectre/v9_0_2/lpmos/mos.scs" section=tm
include "/home/saul/pkg/xfab/XKIT/xh018/cadence/v9_0/spectre/v9_0_2/lpmos/photo.scs" section=tm
include "/home/saul/pkg/xfab/XKIT/xh018/cadence/v9_0/spectre/v9_0_2/lpmos/res.scs" section=tm

// CHARACTERIZATION/BIAS_NMOS_HV/schematic
I0 (0 D) isource dc=IDS type=dc
V1 (net6 0) vsource dc=VDS type=dc
E0 (G 0 D net6) vcvs gain=1000
M0 (D G 0 0) nedia w=WF l=1.25u m=(1)*(NF) par1=(1)*(NF) extlay=0 xf_subext=0
simulatorOptions options temp=27
dcOp dc
