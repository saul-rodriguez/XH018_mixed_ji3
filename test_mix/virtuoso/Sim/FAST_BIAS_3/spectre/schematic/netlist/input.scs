// Design: CHARACTERIZATION/FAST_BIAS_3
simulator lang=spectre
global 0
parameters IDS6=3e-06 IDS3=1e-05 VDS3=1.2 WF3=2e-05 L3=5e-07 NF3=1 IDS2=8e-05 VDS2=0.5 WF2=2e-05 L2=3.5e-07 NF2=10 IDS1=1e-06 VDS1=0.5 WF1=1e-05 L1=1e-06 NF1=10 WF6=1.5e-05 L6=3.5e-07 NF6=1 IDS4=0.0013 VDS6=1.1 WF5=1e-05 L5=3.5e-07 NF5=50 IDS5=0.0026 VDS5=0.5 WF4=1e-05 L4=3.5e-07 NF4=5 VDS4=0.8
include "/home/saul/pkg/xfab/XKIT/xh018/cadence/v9_0/spectre/v9_0_2/lpmos/config.scs" section=default
include "/home/saul/pkg/xfab/XKIT/xh018/cadence/v9_0/spectre/v9_0_2/lpmos/param.scs" section=3s
include "/home/saul/pkg/xfab/XKIT/xh018/cadence/v9_0/spectre/v9_0_2/lpmos/bip.scs" section=tm
include "/home/saul/pkg/xfab/XKIT/xh018/cadence/v9_0/spectre/v9_0_2/lpmos/cap.scs" section=tm
include "/home/saul/pkg/xfab/XKIT/xh018/cadence/v9_0/spectre/v9_0_2/lpmos/dio.scs" section=tm
include "/home/saul/pkg/xfab/XKIT/xh018/cadence/v9_0/spectre/v9_0_2/lpmos/mos.scs" section=tm
include "/home/saul/pkg/xfab/XKIT/xh018/cadence/v9_0/spectre/v9_0_2/lpmos/photo.scs" section=tm
include "/home/saul/pkg/xfab/XKIT/xh018/cadence/v9_0/spectre/v9_0_2/lpmos/res.scs" section=tm

// CHARACTERIZATION/BIAS_NMOS_3/schematic
subckt BIAS_NMOS_3
parameters IDS VDS WF L NF
    I0 (0 D) isource dc=IDS type=dc
    V1 (net6 0) vsource dc=VDS type=dc
    E0 (G 0 D net6) vcvs gain=1000
    M0 (D G 0 0) ne3 w=WF l=L m=(1)*(NF)
ends BIAS_NMOS_3

// CHARACTERIZATION/BIAS_PMOS_3/schematic
subckt BIAS_PMOS_3
parameters WF L NF IDS VDS
    M0 (D G S S) pe3 w=WF l=L m=(1)*(NF)
    E0 (S G net5 D) vcvs gain=1000
    I0 (D S) isource dc=IDS type=dc
    V0 (S 0) vsource dc=1.8 type=dc
    V1 (S net5) vsource dc=VDS type=dc
ends BIAS_PMOS_3

// CHARACTERIZATION/FAST_BIAS_3/schematic
I2 BIAS_NMOS_3 IDS=IDS3 VDS=VDS3 WF=WF3 L=L3 NF=NF3
I1 BIAS_NMOS_3 IDS=IDS2 VDS=VDS2 WF=WF2 L=L2 NF=NF2
I0 BIAS_NMOS_3 IDS=IDS1 VDS=VDS1 WF=WF1 L=L1 NF=NF1
I5 BIAS_PMOS_3 WF=WF6 L=L6 NF=NF6 IDS=IDS4 VDS=VDS6
I4 BIAS_PMOS_3 WF=WF5 L=L5 NF=NF5 IDS=IDS5 VDS=VDS5
I3 BIAS_PMOS_3 WF=WF4 L=L4 NF=NF4 IDS=IDS4 VDS=VDS4
simulatorOptions options temp=27
dcOp dc
