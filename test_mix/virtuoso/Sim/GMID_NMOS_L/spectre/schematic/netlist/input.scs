// Design: CHARACTERIZATION/GMID_NMOS_L
simulator lang=spectre
global 0
parameters IDS1=800u L1=350n NF1=40 VDS1=0.5 WF1=10u
include "/pkg/xfab/XKIT/xh018/cadence/v8_0/spectre/v8_0_1/lpmos/config.scs" section=default
include "/pkg/xfab/XKIT/xh018/cadence/v8_0/spectre/v8_0_1/lpmos/param.scs" section=3s
include "/pkg/xfab/XKIT/xh018/cadence/v8_0/spectre/v8_0_1/lpmos/bip.scs" section=tm
include "/pkg/xfab/XKIT/xh018/cadence/v8_0/spectre/v8_0_1/lpmos/cap.scs" section=tm
include "/pkg/xfab/XKIT/xh018/cadence/v8_0/spectre/v8_0_1/lpmos/dio.scs" section=tm
include "/pkg/xfab/XKIT/xh018/cadence/v8_0/spectre/v8_0_1/lpmos/mos.scs" section=tm
include "/pkg/xfab/XKIT/xh018/cadence/v8_0/spectre/v8_0_1/lpmos/photo.scs" section=tm
include "/pkg/xfab/XKIT/xh018/cadence/v8_0/spectre/v8_0_1/lpmos/res.scs" section=tm

// CHARACTERIZATION/BIAS_NMOS_L/schematic
subckt BIAS_NMOS_L
parameters IDS VDS WF L NF
    I0 (0 D) isource dc=IDS type=dc
    V1 (net6 0) vsource dc=VDS type=dc
    E0 (G 0 D net6) vcvs gain=1000
    M0 (D G 0 0) nel w=WF l=L m=(1)*(NF)
ends BIAS_NMOS_L

// CHARACTERIZATION/GMID_NMOS_L/schematic
I0 BIAS_NMOS_L IDS=IDS1 VDS=VDS1 WF=WF1 L=L1 NF=NF1
simulatorOptions options reltol=100e-6 temp=27 homotopy=all limit=delta
dcOp dc
dc dc param=IDS1 start=10u stop=100u dec=10
save I0.M0.m1:gm I0.M0:gm I0.M0.m1:id I0.M0:id
