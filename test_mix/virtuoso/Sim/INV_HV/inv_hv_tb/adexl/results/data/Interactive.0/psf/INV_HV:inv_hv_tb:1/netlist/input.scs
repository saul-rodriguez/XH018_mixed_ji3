// Design: INV_HV/inv_hv_tb
simulator lang=spectre
global 0
parameters temperature=27
include "/home/saul/pkg/xfab/XKIT/xh018/cadence/v9_0/spectre/v9_0_2/lpmos/config.scs" section=default
include "/home/saul/pkg/xfab/XKIT/xh018/cadence/v9_0/spectre/v9_0_2/lpmos/param.scs" section=3s
include "/home/saul/pkg/xfab/XKIT/xh018/cadence/v9_0/spectre/v9_0_2/lpmos/bip.scs" section=tm
include "/home/saul/pkg/xfab/XKIT/xh018/cadence/v9_0/spectre/v9_0_2/lpmos/cap.scs" section=tm
include "/home/saul/pkg/xfab/XKIT/xh018/cadence/v9_0/spectre/v9_0_2/lpmos/dio.scs" section=tm
include "/home/saul/pkg/xfab/XKIT/xh018/cadence/v9_0/spectre/v9_0_2/lpmos/mos.scs" section=tm
include "/home/saul/pkg/xfab/XKIT/xh018/cadence/v9_0/spectre/v9_0_2/lpmos/photo.scs" section=tm
include "/home/saul/pkg/xfab/XKIT/xh018/cadence/v9_0/spectre/v9_0_2/lpmos/res.scs" section=tm

// INV_HV/inv_hv/schematic
subckt inv_hv GNDHV IN OUT VDDHV VSUB
    M0 (OUT IN GNDHV VSUB) nedia w=10u l=1.25u m=(1)*(1) par1=(1)*(1) extlay=0 xf_subext=0
    R0 (VDDHV OUT VSUB) rpp1k1_3 l=103.425u w=10u m=1 par1=1
ends inv_hv

// INV_HV/inv_hv_tb/schematic
I0 (0 VIN VOUT net1 0) inv_hv
V0 (net1 0) vsource dc=40 type=dc
V1 (VIN 0) vsource type=pulse val0=0 val1=15 period=200u delay=1u rise=1n fall=1n width=100u
C0 (VOUT 0) capacitor c=100.0f
simulatorOptions options temp=27
tran tran stop=1m errpreset=liberal
