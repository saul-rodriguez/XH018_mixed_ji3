// Design: INV_HV/nedia_dc
simulator lang=spectre
global 0
parameters temperature=27 VDS=1 VGS=0
include "/home/saul/pkg/xfab/XKIT/xh018/cadence/v9_0/spectre/v9_0_2/lpmos/config.scs" section=default
include "/home/saul/pkg/xfab/XKIT/xh018/cadence/v9_0/spectre/v9_0_2/lpmos/param.scs" section=3s
include "/home/saul/pkg/xfab/XKIT/xh018/cadence/v9_0/spectre/v9_0_2/lpmos/bip.scs" section=tm
include "/home/saul/pkg/xfab/XKIT/xh018/cadence/v9_0/spectre/v9_0_2/lpmos/cap.scs" section=tm
include "/home/saul/pkg/xfab/XKIT/xh018/cadence/v9_0/spectre/v9_0_2/lpmos/dio.scs" section=tm
include "/home/saul/pkg/xfab/XKIT/xh018/cadence/v9_0/spectre/v9_0_2/lpmos/mos.scs" section=tm
include "/home/saul/pkg/xfab/XKIT/xh018/cadence/v9_0/spectre/v9_0_2/lpmos/photo.scs" section=tm
include "/home/saul/pkg/xfab/XKIT/xh018/cadence/v9_0/spectre/v9_0_2/lpmos/res.scs" section=tm

// INV_HV/nedia_dc/schematic
M0 (net2 net1 0 0) nedia w=200.0000u l=1.25u m=(2)*(1) par1=(2)*(1) extlay=0 xf_subext=0
V1 (net2 0) vsource dc=VDS type=dc
V0 (net1 0) vsource dc=VGS type=dc
simulatorOptions options temp=27
dcOp dc
dc dc param=VDS start=0 stop=40 step=0.1
save M0:1
