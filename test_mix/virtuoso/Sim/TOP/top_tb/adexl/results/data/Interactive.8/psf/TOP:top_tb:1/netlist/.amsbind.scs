// -----------------------------------------------------------------------------
// (c) Copyright 2010 Cadence Design Systems, Inc. All rights reserved worldwide.
// -----------------------------------------------------------------------------

// Binding AMSD Control Block for config TOP.top_tb:config_gate
// Created On: Feb  9 05:08:13 2024
// NOTE      : DO NOT change this system generated file.

amsd {
	config designtop="TOP.top_tb:schematic"

	config cell="counter" lib="COUNTER_JI3" view="schematic"
	config cell="check_gnd" lib="VLG_PRIMITIVES" view="verilogams"
	config cell="check_buf" lib="VLG_PRIMITIVES" view="functional"
	config cell="ioh_pe3isabhv_2800gcr" lib="HV_CELLS" view="schematic"
	config cell="PWRCUTDCPC" lib="IO_CELLS_JIC3V" view="verilogams"
	config cell="vsource" view="analogtext"
	config cell="ioring" lib="IORING" view="schematic"
	config cell="top" lib="TOP" view="schematic"
	config cell="ioh_dhpw_2x100_stack3" lib="HV_CELLS" view="schematic"
	config cell="ON211JI3VX1" lib="D_CELLS_JI3V" view="functional"
	config cell="check_vdd" lib="VLG_PRIMITIVES" view="verilogams"
	config cell="pmb" view="analogtext"
	config cell="ioh_d5pk" lib="HV_CELLS" view="schematic"
	config cell="ioh_dhpw_2x100" lib="HV_CELLS" view="schematic"
	config cell="BUJI3VX16" lib="D_CELLS_JI3V" view="functional"
	config cell="DFRQJI3VX4" lib="D_CELLS_JI3V" view="functional"
	config cell="BUJI3VX2" lib="D_CELLS_JI3V" view="functional"
	config cell="ioh_pmbsab_15_10" lib="HV_CELLS" view="schematic"
	config cell="rdp3" view="analogtext"
	config cell="AN22JI3VX1" lib="D_CELLS_JI3V" view="functional"
	config cell="INJI3VX0" lib="D_CELLS_JI3V" view="functional"
	config cell="ioh_d2pk" lib="HV_CELLS" view="schematic"
	config cell="ne3" view="analogtext"
	config cell="NA2JI3VX0" lib="D_CELLS_JI3V" view="functional"
	config cell="GNDORPADPC" lib="IO_CELLS_JIC3V" view="verilogams"
	config cell="dhpw" view="analogtext"
	config cell="rpp1s" view="analogtext"
	config cell="VDDPADPC" lib="IO_CELLS_JIC3V" view="verilogams"
	config cell="PSUBPADPC" lib="IO_CELLS_JIC3V" view="verilogams"
	config cell="rpp1k1_3" view="analogtext"
	config cell="DECAP25JI3V" lib="D_CELLS_JI3V" view="functional"
	config cell="inv" lib="INV_LP" view="schematic"
	config cell="ioh_c5pk" lib="HV_CELLS" view="schematic"
	config cell="rdp_io" view="analogtext"
	config cell="DFRQJI3VX2" lib="D_CELLS_JI3V" view="functional"
	config cell="HVD4SJD1R5PKFs" lib="HV_CELLS" view="schematic"
	config cell="ioh_pe3isabhv_1050gcr" lib="HV_CELLS" view="schematic"
	config cell="ioh_iscrd2_4x100" lib="HV_CELLS" view="schematic"
	config cell="AN21JI3VX1" lib="D_CELLS_JI3V" view="functional"
	config cell="dpdnw" view="analogtext"
	config cell="VDDORPADPC" lib="IO_CELLS_JIC3V" view="verilogams"
	config cell="ioh_pmbsabhv_750" lib="HV_CELLS" view="schematic"
	config cell="NO2JI3VX0" lib="D_CELLS_JI3V" view="functional"
	config cell="dp3" view="analogtext"
	config cell="dpdd_scr" view="analogtext"
	config cell="APR04DPC" lib="IO_CELLS_JIC3V" view="verilogams"
	config cell="ioh_pmbsab_40_10" lib="HV_CELLS" view="schematic"
	config cell="DECAP5JI3V" lib="D_CELLS_JI3V" view="functional"
	config cell="DLY2JI3VX1" lib="D_CELLS_JI3V" view="functional"
	config cell="ioh_pe3isab_15_04" lib="HV_CELLS" view="schematic"
	config cell="HVDD4DJ5PKFs" lib="HV_CELLS" view="schematic"
	config cell="u1_fd5" lib="VLG_PRIMITIVES" view="functional"
	config cell="DECAP7JI3V" lib="D_CELLS_JI3V" view="functional"
	config cell="BUJI3VX0" lib="D_CELLS_JI3V" view="functional"
	config cell="resistor" view="analogtext"
	config cell="ioh_pmbsabhv_2000" lib="HV_CELLS" view="schematic"
	config cell="EN2JI3VX0" lib="D_CELLS_JI3V" view="functional"
	config cell="BUJI3VX1" lib="D_CELLS_JI3V" view="functional"
	config cell="DECAP15JI3V" lib="D_CELLS_JI3V" view="functional"
	config cell="ICPC" lib="IO_CELLS_JIC3V" view="verilogams"
	config cell="dphnw" view="analogtext"
	config cell="nedia" view="analogtext"
	config cell="pe3" view="analogtext"
	config cell="dnpdd_scr" view="analogtext"
	config cell="rnp1" view="analogtext"
	config cell="resistor_ams" lib="VLG_PRIMITIVES" view="verilogams"
	config cell="ioh_pe3isab_40_04" lib="HV_CELLS" view="schematic"
	config cell="DECAP10JI3V" lib="D_CELLS_JI3V" view="functional"
	config cell="HVDD4D2PK" lib="HV_CELLS" view="schematic"
	config cell="ddnw" view="analogtext"
	config cell="APR00DPC" lib="IO_CELLS_JIC3V" view="verilogams"
	config cell="DLY1JI3VX1" lib="D_CELLS_JI3V" view="functional"
	config cell="DFRQJI3VX1" lib="D_CELLS_JI3V" view="functional"
	config cell="inv_hv" lib="INV_HV" view="schematic"
	config cell="counter_stimulus" lib="COUNTER_JI3" view="verilogams_sdf"
	config cell="BT4PC" lib="IO_CELLS_JIC3V" view="verilogams"
	config cell="GNDPADPC" lib="IO_CELLS_JIC3V" view="verilogams"
	config cell="pe3i" view="analogtext"

 }
