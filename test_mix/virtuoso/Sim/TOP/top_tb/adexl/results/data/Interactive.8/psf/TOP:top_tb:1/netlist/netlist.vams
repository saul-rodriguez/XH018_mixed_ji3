// AMS netlist generated by the AMS Unified netlister
// IC subversion:  IC6.1.8-64b.500.34
// Xcelium version: 23.09-s002
// Copyright(C) 2005-2009, Cadence Design Systems, Inc
// User: saul Pid: 22965
// Design library name: TOP
// Design cell name: top_tb
// Design view name: config_gate
// Solver: Spectre

`include "disciplines.vams"
`include "userDisciplines.vams"
// HDL file - COUNTER_JI3, counter_stimulus, verilogams_sdf.
// HDL file - D_CELLS_JI3V, BUJI3VX0, functional.
// HDL file - D_CELLS_JI3V, BUJI3VX16, functional.
// HDL file - D_CELLS_JI3V, ON211JI3VX1, functional.
// HDL file - D_CELLS_JI3V, DLY1JI3VX1, functional.
// HDL file - D_CELLS_JI3V, AN21JI3VX1, functional.
// HDL file - D_CELLS_JI3V, AN22JI3VX1, functional.
// HDL file - D_CELLS_JI3V, EN2JI3VX0, functional.
// HDL file - D_CELLS_JI3V, NO2JI3VX0, functional.
// HDL file - VLG_PRIMITIVES, u1_fd5, functional.
// HDL file - D_CELLS_JI3V, BUJI3VX1, functional.
// HDL file - D_CELLS_JI3V, DECAP25JI3V, functional.
// HDL file - D_CELLS_JI3V, DECAP15JI3V, functional.
// HDL file - D_CELLS_JI3V, DECAP10JI3V, functional.
// HDL file - D_CELLS_JI3V, DECAP7JI3V, functional.
// HDL file - D_CELLS_JI3V, DECAP5JI3V, functional.
// HDL file - D_CELLS_JI3V, BUJI3VX2, functional.
// HDL file - D_CELLS_JI3V, DLY2JI3VX1, functional.
// HDL file - D_CELLS_JI3V, INJI3VX0, functional.
// HDL file - D_CELLS_JI3V, NA2JI3VX0, functional.
// HDL file - IO_CELLS_JIC3V, APR00DPC, verilogams.
// HDL file - VLG_PRIMITIVES, resistor_ams, verilogams.
// HDL file - IO_CELLS_JIC3V, PWRCUTDCPC, verilogams.
// HDL file - VLG_PRIMITIVES, check_vdd, verilogams.
// HDL file - VLG_PRIMITIVES, check_buf, functional.
// HDL file - VLG_PRIMITIVES, check_gnd, verilogams.
// HDL file - IO_CELLS_JIC3V, GNDPADPC, verilogams.
// HDL file - IO_CELLS_JIC3V, PSUBPADPC, verilogams.
// HDL file - IO_CELLS_JIC3V, GNDORPADPC, verilogams.
// HDL file - IO_CELLS_JIC3V, VDDPADPC, verilogams.
// HDL file - IO_CELLS_JIC3V, VDDORPADPC, verilogams.
// HDL file - IO_CELLS_JIC3V, ICPC, verilogams.
// HDL file - IO_CELLS_JIC3V, BT4PC, verilogams.
// HDL file - IO_CELLS_JIC3V, APR04DPC, verilogams.
// HDL file - D_CELLS_JI3V, DFRQJI3VX1, functional.
// HDL file - D_CELLS_JI3V, DFRQJI3VX2, functional.
// HDL file - D_CELLS_JI3V, DFRQJI3VX4, functional.
// Library - COUNTER_JI3, Cell - counter, View - schematic
// LAST TIME SAVED: Feb  3 16:10:44 2024
// NETLIST TIME: Feb  9 05:08:09 2024

`worklib COUNTER_JI3
`view schematic

`timescale 1ns / 1ps
(* cds_ams_schematic *)

module counter (out, enable, clk, reset);
input  clk, enable, reset;
output [7:0] out;
wire n_1;
wire n_6;
wire n_5;
wire n_0;
wire n_2;
wire n_7;
wire n_3;
wire n_12;
wire n_15;
wire FE_OFN0_out_0;
wire n_10;
wire n_29;
wire n_32;
wire n_25;
wire n_28;
wire n_17;
wire n_20;
wire n_21;
wire n_24;
wire FE_PHN2_enable;
wire FE_PHN5_n_22;
wire n_22;
wire FE_PHN4_n_18;
wire n_18;
wire FE_PHN3_n_14;
wire n_14;
wire FE_PHN1_reset;
wire FE_PHN10_n_38;
wire n_38;
wire CTS_1;
wire CTS_2;
wire n_36;
wire n_9;
wire n_33;
wire FE_PHN9_n_37;
wire FE_PHN8_n_34;
wire FE_PHN6_n_26;
wire FE_PHN7_n_30;
wire n_19;
wire n_13;
wire n_35;
wire n_37;
wire n_31;
wire n_34;
wire n_23;
wire n_26;
wire n_27;
wire n_30;
NA2JI3VX0 g225__6417 (.B( n_6 ), .Q( n_1 ), .A( out[2] ));
NA2JI3VX0 g222__2346 (.B( n_6 ), .Q( n_5 ), .A( out[1] ));
NA2JI3VX0 g224__5477 (.B( n_6 ), .Q( n_0 ), .A( out[6] ));
NA2JI3VX0 g226__7410 (.B( n_6 ), .Q( n_2 ), .A( out[5] ));
NA2JI3VX0 g221__2883 (.B( n_6 ), .Q( n_7 ), .A( out[3] ));
NA2JI3VX0 g223__1666 (.B( n_6 ), .Q( n_3 ), .A( out[4] ));
NA2JI3VX0 g217__9315 (.B( out[2] ), .Q( n_15 ), .A( n_12 ));
NA2JI3VX0 g227__2398 (.B( out[1] ), .Q( n_10 ), .A( FE_OFN0_out_0 ));
NA2JI3VX0 g197__1617 (.B( out[6] ), .Q( n_32 ), .A( n_29 ));
NA2JI3VX0 g202__5122 (.B( out[5] ), .Q( n_28 ), .A( n_25 ));
NA2JI3VX0 g212__7482 (.B( out[3] ), .Q( n_20 ), .A( n_17 ));
NA2JI3VX0 g207__6131 (.B( out[4] ), .Q( n_24 ), .A( n_21 ));
INJI3VX0 g218 (.A( n_10 ), .Q( n_12 ));
INJI3VX0 g213 (.A( n_15 ), .Q( n_17 ));
INJI3VX0 g232 (.A( FE_PHN2_enable ), .Q( n_6 ));
INJI3VX0 g198 (.A( n_28 ), .Q( n_29 ));
INJI3VX0 g203 (.A( n_24 ), .Q( n_25 ));
INJI3VX0 g208 (.A( n_20 ), .Q( n_21 ));
DLY2JI3VX1 FE_PHC5_n_22 (.A( n_22 ), .Q( FE_PHN5_n_22 ));
DLY2JI3VX1 FE_PHC4_n_18 (.A( n_18 ), .Q( FE_PHN4_n_18 ));
DLY2JI3VX1 FE_PHC3_n_14 (.A( n_14 ), .Q( FE_PHN3_n_14 ));
DLY2JI3VX1 FE_PHC2_enable (.A( enable ), .Q( FE_PHN2_enable ));
DLY2JI3VX1 FE_PHC1_reset (.A( reset ), .Q( FE_PHN1_reset ));
BUJI3VX2 FE_PHC10_n_38 (.A( n_38 ), .Q( FE_PHN10_n_38 ));
BUJI3VX2 FE_OFC0_out_0 (.A( FE_OFN0_out_0 ), .Q( out[0] ));
DECAP5JI3V FILLCAP_T_1_6 ();
DECAP5JI3V FILLCAP_T_1_8 ();
DECAP5JI3V FILLCAP_T_1_10 ();
DECAP5JI3V FILLCAP_T_1_12 ();
DECAP5JI3V FILLCAP_T_1_17 ();
DECAP5JI3V FILLCAP_T_1_21 ();
DECAP5JI3V FILLCAP_T_1_24 ();
DECAP5JI3V FILLCAP_T_1_30 ();
DECAP5JI3V FILLCAP_T_1_34 ();
DECAP5JI3V FILLCAP_T_1_35 ();
DECAP5JI3V FILLCAP_T_1_38 ();
DECAP7JI3V FILLCAP_T_1_3 ();
DECAP7JI3V FILLCAP_T_1_13 ();
DECAP7JI3V FILLCAP_T_1_14 ();
DECAP7JI3V FILLCAP_T_1_15 ();
DECAP7JI3V FILLCAP_T_1_16 ();
DECAP7JI3V FILLCAP_T_1_18 ();
DECAP7JI3V FILLCAP_T_1_19 ();
DECAP7JI3V FILLCAP_T_1_20 ();
DECAP7JI3V FILLCAP_T_1_22 ();
DECAP7JI3V FILLCAP_T_1_25 ();
DECAP7JI3V FILLCAP_T_1_26 ();
DECAP7JI3V FILLCAP_T_1_27 ();
DECAP7JI3V FILLCAP_T_1_28 ();
DECAP7JI3V FILLCAP_T_1_29 ();
DECAP7JI3V FILLCAP_T_1_31 ();
DECAP7JI3V FILLCAP_T_1_32 ();
DECAP7JI3V FILLCAP_T_1_33 ();
DECAP7JI3V FILLCAP_T_1_37 ();
DECAP10JI3V FILLCAP_T_1_2 ();
DECAP10JI3V FILLCAP_T_1_4 ();
DECAP10JI3V FILLCAP_T_1_9 ();
DECAP10JI3V FILLCAP_T_1_23 ();
DECAP10JI3V FILLCAP_T_1_36 ();
DECAP15JI3V FILLCAP_T_1_5 ();
DECAP15JI3V FILLCAP_T_1_7 ();
DECAP15JI3V FILLCAP_T_1_11 ();
DECAP25JI3V FILLCAP_T_1_1 ();
BUJI3VX1 CTS_cdb_buf_00009 (.A( CTS_2 ), .Q( CTS_1 ));
BUJI3VX1 CTS_cdb_buf_00010 (.A( clk ), .Q( CTS_2 ));
DFRQJI3VX1 \out_reg[0]  (.Q( FE_OFN0_out_0 ), .D( FE_PHN3_n_14 ), .C( CTS_1 ));
NO2JI3VX0 g187__2398 (.B( n_36 ), .A( FE_PHN1_reset ), .Q( n_38 ));
NO2JI3VX0 g219__4733 (.B( n_9 ), .A( FE_PHN1_reset ), .Q( n_14 ));
EN2JI3VX0 g191__5526 (.A( out[7] ), .B( n_32 ), .Q( n_33 ));
EN2JI3VX0 g220__9945 (.A( FE_PHN2_enable ), .B( FE_OFN0_out_0 ), .Q( n_9 ));
DFRQJI3VX2 \out_reg[2]  (.Q( out[2] ), .D( FE_PHN5_n_22 ), .C( CTS_1 ));
DFRQJI3VX2 \out_reg[6]  (.Q( out[6] ), .D( FE_PHN9_n_37 ), .C( CTS_1 ));
DFRQJI3VX2 \out_reg[5]  (.Q( out[5] ), .D( FE_PHN8_n_34 ), .C( CTS_1 ));
DFRQJI3VX2 \out_reg[3]  (.Q( out[3] ), .D( FE_PHN6_n_26 ), .C( CTS_1 ));
DFRQJI3VX2 \out_reg[4]  (.Q( out[4] ), .D( FE_PHN7_n_30 ), .C( CTS_1 ));
DFRQJI3VX2 \out_reg[7]  (.Q( out[7] ), .D( FE_PHN10_n_38 ), .C( CTS_1 ));
AN22JI3VX1 g189__6260 (.Q( n_36 ), .D( n_6 ), .C( out[7] ), .A( n_33 ), .B( FE_PHN2_enable ));
AN21JI3VX1 g209__7098 (.Q( n_22 ), .C( FE_PHN1_reset ), .A( n_19 ), .B( n_1 ));
AN21JI3VX1 g214__5115 (.Q( n_18 ), .C( FE_PHN1_reset ), .A( n_13 ), .B( n_5 ));
AN21JI3VX1 g190__5107 (.Q( n_37 ), .C( FE_PHN1_reset ), .A( n_35 ), .B( n_0 ));
AN21JI3VX1 g194__8428 (.Q( n_34 ), .C( FE_PHN1_reset ), .A( n_31 ), .B( n_2 ));
AN21JI3VX1 g204__1705 (.Q( n_26 ), .C( FE_PHN1_reset ), .A( n_23 ), .B( n_7 ));
AN21JI3VX1 g199__3680 (.Q( n_30 ), .C( FE_PHN1_reset ), .A( n_27 ), .B( n_3 ));
DLY1JI3VX1 FE_PHC6_n_26 (.A( n_26 ), .Q( FE_PHN6_n_26 ));
DLY1JI3VX1 FE_PHC7_n_30 (.A( n_30 ), .Q( FE_PHN7_n_30 ));
ON211JI3VX1 g211__1881 (.D( FE_PHN2_enable ), .Q( n_19 ), .C( n_15 ), .A( n_12 ), .B( out[2] ));
ON211JI3VX1 g216__6161 (.D( FE_PHN2_enable ), .Q( n_13 ), .C( n_10 ), .A( out[0] ), .B( out[1] ));
ON211JI3VX1 g193__4319 (.D( FE_PHN2_enable ), .Q( n_35 ), .C( n_32 ), .A( n_29 ), .B( out[6] ));
ON211JI3VX1 g196__6783 (.D( FE_PHN2_enable ), .Q( n_31 ), .C( n_28 ), .A( n_25 ), .B( out[5] ));
ON211JI3VX1 g206__8246 (.D( FE_PHN2_enable ), .Q( n_23 ), .C( n_20 ), .A( n_17 ), .B( out[3] ));
ON211JI3VX1 g201__2802 (.D( FE_PHN2_enable ), .Q( n_27 ), .C( n_24 ), .A( n_21 ), .B( out[4] ));
BUJI3VX16 FE_PHC8_n_34 (.A( n_34 ), .Q( FE_PHN8_n_34 ));
BUJI3VX0 FE_PHC9_n_37 (.A( n_37 ), .Q( FE_PHN9_n_37 ));
DFRQJI3VX4 \out_reg[1]  (.Q( out[1] ), .D( FE_PHN4_n_18 ), .C( CTS_1 ));

endmodule
// Library - HV_CELLS, Cell - HVDD4DJ5PKFs, View - schematic
// LAST TIME SAVED: Feb 25 05:55:38 2015
// NETLIST TIME: Feb  9 05:08:09 2024

`worklib HV_CELLS
`view schematic

`timescale 1ns / 1ps
(* cds_ams_schematic *)

module HVDD4DJ5PKFs (GNDO, IGND, PAD);
inout  GNDO, IGND, PAD;
ioh_dhpw_2x100_stack3 I9 (.A_l( IGND ), .Sub( GNDO ), .K_h( PAD ));
ioh_d5pk I11 (.Sub( GNDO ), .K_h( PAD ), .A_l( IGND ));

endmodule
// Library - HV_CELLS, Cell - ioh_d2pk, View - schematic
// LAST TIME SAVED: Feb 25 05:55:50 2015
// NETLIST TIME: Feb  9 05:08:09 2024

`worklib HV_CELLS
`view schematic

`timescale 1ns / 1ps
(* cds_ams_schematic *)

module ioh_d2pk (A_l, K_h, Sub);
inout  A_l, K_h, Sub;
wire net12;
ioh_pmbsabhv_2000 I1 (.GSB( K_h ), .Sub( Sub ), .D( net12 ));
ioh_pe3isabhv_2800gcr I5 (.Sub( Sub ), .SB( net12 ), .D( A_l ));

endmodule
// Library - HV_CELLS, Cell - HVDD4D2PK, View - schematic
// LAST TIME SAVED: Feb 25 05:55:34 2015
// NETLIST TIME: Feb  9 05:08:09 2024

`worklib HV_CELLS
`view schematic

`timescale 1ns / 1ps
(* cds_ams_schematic *)

module HVDD4D2PK (GND, PAD);
inout  GND, PAD;
ioh_d2pk I11 (.Sub( GND ), .K_h( PAD ), .A_l( GND ));
ddnw #(.area(3.89668e-10), .perimeter(0.0002085), .dbv(0), .m(1), .par1(1), .xf_subext(0))
(* integer passed_mfactor = "m"; *)
 D0 (GND, PAD);

endmodule
// Library - HV_CELLS, Cell - ioh_iscrd2_4x100, View - schematic
// LAST TIME SAVED: Feb 25 05:55:54 2015
// NETLIST TIME: Feb  9 05:08:09 2024

`worklib HV_CELLS
`view schematic

`timescale 1ns / 1ps
(* cds_ams_schematic *)

module ioh_iscrd2_4x100 (A, Gn, Gp, K, Sub);
inout  A, Gn, Gp, K, Sub;
dnpdd_scr #(.area(5.36386e-10), .perimeter(0.00040956), .dbv(0), .m(1))
(* integer passed_mfactor = "m"; *)
 D1 (Gp, K);
dpdd_scr #(.area(2.19633e-09), .perimeter(0.00045716), .dbv(0), .m(1))
(* integer passed_mfactor = "m"; *)
 D2 (Gp, Gn);
dpdnw #(.area(1.89063e-10), .perimeter(0.00020378), .dbv(0), .m(4), .par1(4))
(* integer passed_mfactor = "m"; *)
 D0 (A, Gn);
ddnw #(.area(6.92224e-09), .perimeter(0.00035917), .dbv(0), .m(1), .par1(1), .xf_subext(0))
(* integer passed_mfactor = "m"; *)
 D_Guard (Sub, Gn);

endmodule
// Library - HV_CELLS, Cell - ioh_pe3isab_15_04, View - schematic
// LAST TIME SAVED: Feb 25 05:55:55 2015
// NETLIST TIME: Feb  9 05:08:09 2024

`worklib HV_CELLS
`view schematic

`timescale 1ns / 1ps
(* cds_ams_schematic *)

module ioh_pe3isab_15_04 (B, D, G, S);
inout  B, D, G, S;
pe3i #(.w(1.5e-05), .l(4e-07), .as(7.2e-12), .ad(7.2e-12), .ps(3.096e-05), .pd(3.096e-05), .nrs(0.018), .nrd(0.018), .m((1)*(1)), .par1((1)*(1)))
(* integer passed_mfactor = "m"; *)
 MPX (net17, G, S, B);
rdp3 #(.l(4.3e-07), .w(1.5e-05), .m(1), .par1(1))
(* integer passed_mfactor = "m"; *)
 R0 (net17, D, B);

endmodule
// Library - HV_CELLS, Cell - ioh_pe3isabhv_1050gcr, View - schematic
// LAST TIME SAVED: Feb 25 05:55:55 2015
// NETLIST TIME: Feb  9 05:08:09 2024

`worklib HV_CELLS
`view schematic

`timescale 1ns / 1ps
(* cds_ams_schematic *)

module ioh_pe3isabhv_1050gcr (D, SB, Sub);
inout  D, SB, Sub;
wire net20;
ioh_pe3isab_15_04 MP_1 (.D( D ), .B( SB ), .G( net20 ), .S( SB ));
ioh_pe3isab_15_04 MP_2 (.D( D ), .B( SB ), .G( net20 ), .S( SB ));
ioh_pe3isab_15_04 MP_3 (.D( D ), .B( SB ), .G( net20 ), .S( SB ));
ioh_pe3isab_15_04 MP_4 (.D( D ), .B( SB ), .G( net20 ), .S( SB ));
ioh_pe3isab_15_04 MP_5 (.D( D ), .B( SB ), .G( net20 ), .S( SB ));
ioh_pe3isab_15_04 MP_6 (.D( D ), .B( SB ), .G( net20 ), .S( SB ));
ioh_pe3isab_15_04 MP_7 (.D( D ), .B( SB ), .G( net20 ), .S( SB ));
ioh_pe3isab_15_04 MP_8 (.D( D ), .B( SB ), .G( net20 ), .S( SB ));
ioh_pe3isab_15_04 MP_9 (.D( D ), .B( SB ), .G( net20 ), .S( SB ));
ioh_pe3isab_15_04 MP_10 (.D( D ), .B( SB ), .G( net20 ), .S( SB ));
ioh_pe3isab_15_04 MP_11 (.D( D ), .B( SB ), .G( net20 ), .S( SB ));
ioh_pe3isab_15_04 MP_12 (.D( D ), .B( SB ), .G( net20 ), .S( SB ));
ioh_pe3isab_15_04 MP_13 (.D( D ), .B( SB ), .G( net20 ), .S( SB ));
ioh_pe3isab_15_04 MP_14 (.D( D ), .B( SB ), .G( net20 ), .S( SB ));
ioh_pe3isab_15_04 MP_15 (.D( D ), .B( SB ), .G( net20 ), .S( SB ));
ioh_pe3isab_15_04 MP_16 (.D( D ), .B( SB ), .G( net20 ), .S( SB ));
ioh_pe3isab_15_04 MP_17 (.D( D ), .B( SB ), .G( net20 ), .S( SB ));
ioh_pe3isab_15_04 MP_18 (.D( D ), .B( SB ), .G( net20 ), .S( SB ));
ioh_pe3isab_15_04 MP_19 (.D( D ), .B( SB ), .G( net20 ), .S( SB ));
ioh_pe3isab_15_04 MP_20 (.D( D ), .B( SB ), .G( net20 ), .S( SB ));
ioh_pe3isab_15_04 MP_21 (.D( D ), .B( SB ), .G( net20 ), .S( SB ));
ioh_pe3isab_15_04 MP_22 (.D( D ), .B( SB ), .G( net20 ), .S( SB ));
ioh_pe3isab_15_04 MP_23 (.D( D ), .B( SB ), .G( net20 ), .S( SB ));
ioh_pe3isab_15_04 MP_24 (.D( D ), .B( SB ), .G( net20 ), .S( SB ));
ioh_pe3isab_15_04 MP_25 (.D( D ), .B( SB ), .G( net20 ), .S( SB ));
ioh_pe3isab_15_04 MP_26 (.D( D ), .B( SB ), .G( net20 ), .S( SB ));
ioh_pe3isab_15_04 MP_27 (.D( D ), .B( SB ), .G( net20 ), .S( SB ));
ioh_pe3isab_15_04 MP_28 (.D( D ), .B( SB ), .G( net20 ), .S( SB ));
ioh_pe3isab_15_04 MP_29 (.D( D ), .B( SB ), .G( net20 ), .S( SB ));
ioh_pe3isab_15_04 MP_30 (.D( D ), .B( SB ), .G( net20 ), .S( SB ));
ioh_pe3isab_15_04 MP_31 (.D( D ), .B( SB ), .G( net20 ), .S( SB ));
ioh_pe3isab_15_04 MP_32 (.D( D ), .B( SB ), .G( net20 ), .S( SB ));
ioh_pe3isab_15_04 MP_33 (.D( D ), .B( SB ), .G( net20 ), .S( SB ));
ioh_pe3isab_15_04 MP_34 (.D( D ), .B( SB ), .G( net20 ), .S( SB ));
ioh_pe3isab_15_04 MP_35 (.D( D ), .B( SB ), .G( net20 ), .S( SB ));
ioh_pe3isab_15_04 MP_36 (.D( D ), .B( SB ), .G( net20 ), .S( SB ));
ioh_pe3isab_15_04 MP_37 (.D( D ), .B( SB ), .G( net20 ), .S( SB ));
ioh_pe3isab_15_04 MP_38 (.D( D ), .B( SB ), .G( net20 ), .S( SB ));
ioh_pe3isab_15_04 MP_39 (.D( D ), .B( SB ), .G( net20 ), .S( SB ));
ioh_pe3isab_15_04 MP_40 (.D( D ), .B( SB ), .G( net20 ), .S( SB ));
ioh_pe3isab_15_04 MP_41 (.D( D ), .B( SB ), .G( net20 ), .S( SB ));
ioh_pe3isab_15_04 MP_42 (.D( D ), .B( SB ), .G( net20 ), .S( SB ));
ioh_pe3isab_15_04 MP_43 (.D( D ), .B( SB ), .G( net20 ), .S( SB ));
ioh_pe3isab_15_04 MP_44 (.D( D ), .B( SB ), .G( net20 ), .S( SB ));
ioh_pe3isab_15_04 MP_45 (.D( D ), .B( SB ), .G( net20 ), .S( SB ));
ioh_pe3isab_15_04 MP_46 (.D( D ), .B( SB ), .G( net20 ), .S( SB ));
ioh_pe3isab_15_04 MP_47 (.D( D ), .B( SB ), .G( net20 ), .S( SB ));
ioh_pe3isab_15_04 MP_48 (.D( D ), .B( SB ), .G( net20 ), .S( SB ));
ioh_pe3isab_15_04 MP_49 (.D( D ), .B( SB ), .G( net20 ), .S( SB ));
ioh_pe3isab_15_04 MP_50 (.D( D ), .B( SB ), .G( net20 ), .S( SB ));
ioh_pe3isab_15_04 MP_51 (.D( D ), .B( SB ), .G( net20 ), .S( SB ));
ioh_pe3isab_15_04 MP_52 (.D( D ), .B( SB ), .G( net20 ), .S( SB ));
ioh_pe3isab_15_04 MP_53 (.D( D ), .B( SB ), .G( net20 ), .S( SB ));
ioh_pe3isab_15_04 MP_54 (.D( D ), .B( SB ), .G( net20 ), .S( SB ));
ioh_pe3isab_15_04 MP_55 (.D( D ), .B( SB ), .G( net20 ), .S( SB ));
ioh_pe3isab_15_04 MP_56 (.D( D ), .B( SB ), .G( net20 ), .S( SB ));
ioh_pe3isab_15_04 MP_57 (.D( D ), .B( SB ), .G( net20 ), .S( SB ));
ioh_pe3isab_15_04 MP_58 (.D( D ), .B( SB ), .G( net20 ), .S( SB ));
ioh_pe3isab_15_04 MP_59 (.D( D ), .B( SB ), .G( net20 ), .S( SB ));
ioh_pe3isab_15_04 MP_60 (.D( D ), .B( SB ), .G( net20 ), .S( SB ));
ioh_pe3isab_15_04 MP_61 (.D( D ), .B( SB ), .G( net20 ), .S( SB ));
ioh_pe3isab_15_04 MP_62 (.D( D ), .B( SB ), .G( net20 ), .S( SB ));
ioh_pe3isab_15_04 MP_63 (.D( D ), .B( SB ), .G( net20 ), .S( SB ));
ioh_pe3isab_15_04 MP_64 (.D( D ), .B( SB ), .G( net20 ), .S( SB ));
ioh_pe3isab_15_04 MP_65 (.D( D ), .B( SB ), .G( net20 ), .S( SB ));
ioh_pe3isab_15_04 MP_66 (.D( D ), .B( SB ), .G( net20 ), .S( SB ));
ioh_pe3isab_15_04 MP_67 (.D( D ), .B( SB ), .G( net20 ), .S( SB ));
ioh_pe3isab_15_04 MP_68 (.D( D ), .B( SB ), .G( net20 ), .S( SB ));
ioh_pe3isab_15_04 MP_69 (.D( D ), .B( SB ), .G( net20 ), .S( SB ));
ioh_pe3isab_15_04 MP_70 (.D( D ), .B( SB ), .G( net20 ), .S( SB ));
dp3 #(.area(9.89102e-12), .perimeter(1.32e-06), .dbv(0), .m(1), .par1(1))
(* integer passed_mfactor = "m"; *)
 MD_1 (D, SB);
dp3 #(.area(9.89102e-12), .perimeter(1.32e-06), .dbv(0), .m(1), .par1(1))
(* integer passed_mfactor = "m"; *)
 MD_2 (D, SB);
dp3 #(.area(9.89102e-12), .perimeter(1.32e-06), .dbv(0), .m(1), .par1(1))
(* integer passed_mfactor = "m"; *)
 MD_3 (D, SB);
dp3 #(.area(9.89102e-12), .perimeter(1.32e-06), .dbv(0), .m(1), .par1(1))
(* integer passed_mfactor = "m"; *)
 MD_4 (D, SB);
dp3 #(.area(9.89102e-12), .perimeter(1.32e-06), .dbv(0), .m(1), .par1(1))
(* integer passed_mfactor = "m"; *)
 MD_5 (D, SB);
dp3 #(.area(9.89102e-12), .perimeter(1.32e-06), .dbv(0), .m(1), .par1(1))
(* integer passed_mfactor = "m"; *)
 MD_6 (D, SB);
dp3 #(.area(9.89102e-12), .perimeter(1.32e-06), .dbv(0), .m(1), .par1(1))
(* integer passed_mfactor = "m"; *)
 MD_7 (D, SB);
dp3 #(.area(9.89102e-12), .perimeter(1.32e-06), .dbv(0), .m(1), .par1(1))
(* integer passed_mfactor = "m"; *)
 MD_8 (D, SB);
dp3 #(.area(9.89102e-12), .perimeter(1.32e-06), .dbv(0), .m(1), .par1(1))
(* integer passed_mfactor = "m"; *)
 MD_9 (D, SB);
dp3 #(.area(9.89102e-12), .perimeter(1.32e-06), .dbv(0), .m(1), .par1(1))
(* integer passed_mfactor = "m"; *)
 MD_10 (D, SB);
dp3 #(.area(9.89102e-12), .perimeter(1.32e-06), .dbv(0), .m(1), .par1(1))
(* integer passed_mfactor = "m"; *)
 MD_11 (D, SB);
dp3 #(.area(9.89102e-12), .perimeter(1.32e-06), .dbv(0), .m(1), .par1(1))
(* integer passed_mfactor = "m"; *)
 MD_12 (D, SB);
dp3 #(.area(9.89102e-12), .perimeter(1.32e-06), .dbv(0), .m(1), .par1(1))
(* integer passed_mfactor = "m"; *)
 MD_13 (D, SB);
dp3 #(.area(9.89102e-12), .perimeter(1.32e-06), .dbv(0), .m(1), .par1(1))
(* integer passed_mfactor = "m"; *)
 MD_14 (D, SB);
dp3 #(.area(9.89102e-12), .perimeter(1.32e-06), .dbv(0), .m(1), .par1(1))
(* integer passed_mfactor = "m"; *)
 MD_15 (D, SB);
dp3 #(.area(9.89102e-12), .perimeter(1.32e-06), .dbv(0), .m(1), .par1(1))
(* integer passed_mfactor = "m"; *)
 MD_16 (D, SB);
dp3 #(.area(9.89102e-12), .perimeter(1.32e-06), .dbv(0), .m(1), .par1(1))
(* integer passed_mfactor = "m"; *)
 MD_17 (D, SB);
dp3 #(.area(9.89102e-12), .perimeter(1.32e-06), .dbv(0), .m(1), .par1(1))
(* integer passed_mfactor = "m"; *)
 MD_18 (D, SB);
dp3 #(.area(9.89102e-12), .perimeter(1.32e-06), .dbv(0), .m(1), .par1(1))
(* integer passed_mfactor = "m"; *)
 MD_19 (D, SB);
dp3 #(.area(9.89102e-12), .perimeter(1.32e-06), .dbv(0), .m(1), .par1(1))
(* integer passed_mfactor = "m"; *)
 MD_20 (D, SB);
dp3 #(.area(9.89102e-12), .perimeter(1.32e-06), .dbv(0), .m(1), .par1(1))
(* integer passed_mfactor = "m"; *)
 MD_21 (D, SB);
dp3 #(.area(9.89102e-12), .perimeter(1.32e-06), .dbv(0), .m(1), .par1(1))
(* integer passed_mfactor = "m"; *)
 MD_22 (D, SB);
dp3 #(.area(9.89102e-12), .perimeter(1.32e-06), .dbv(0), .m(1), .par1(1))
(* integer passed_mfactor = "m"; *)
 MD_23 (D, SB);
dp3 #(.area(9.89102e-12), .perimeter(1.32e-06), .dbv(0), .m(1), .par1(1))
(* integer passed_mfactor = "m"; *)
 MD_24 (D, SB);
dp3 #(.area(9.89102e-12), .perimeter(1.32e-06), .dbv(0), .m(1), .par1(1))
(* integer passed_mfactor = "m"; *)
 MD_25 (D, SB);
dp3 #(.area(9.89102e-12), .perimeter(1.32e-06), .dbv(0), .m(1), .par1(1))
(* integer passed_mfactor = "m"; *)
 MD_26 (D, SB);
dp3 #(.area(9.89102e-12), .perimeter(1.32e-06), .dbv(0), .m(1), .par1(1))
(* integer passed_mfactor = "m"; *)
 MD_27 (D, SB);
dp3 #(.area(9.89102e-12), .perimeter(1.32e-06), .dbv(0), .m(1), .par1(1))
(* integer passed_mfactor = "m"; *)
 MD_28 (D, SB);
dp3 #(.area(9.89102e-12), .perimeter(1.32e-06), .dbv(0), .m(1), .par1(1))
(* integer passed_mfactor = "m"; *)
 MD_29 (D, SB);
dp3 #(.area(9.89102e-12), .perimeter(1.32e-06), .dbv(0), .m(1), .par1(1))
(* integer passed_mfactor = "m"; *)
 MD_30 (D, SB);
dp3 #(.area(9.89102e-12), .perimeter(1.32e-06), .dbv(0), .m(1), .par1(1))
(* integer passed_mfactor = "m"; *)
 MD_31 (D, SB);
dp3 #(.area(9.89102e-12), .perimeter(1.32e-06), .dbv(0), .m(1), .par1(1))
(* integer passed_mfactor = "m"; *)
 MD_32 (D, SB);
dp3 #(.area(9.89102e-12), .perimeter(1.32e-06), .dbv(0), .m(1), .par1(1))
(* integer passed_mfactor = "m"; *)
 MD_33 (D, SB);
dp3 #(.area(9.89102e-12), .perimeter(1.32e-06), .dbv(0), .m(1), .par1(1))
(* integer passed_mfactor = "m"; *)
 MD_34 (D, SB);
dp3 #(.area(9.89102e-12), .perimeter(1.32e-06), .dbv(0), .m(1), .par1(1))
(* integer passed_mfactor = "m"; *)
 MD_35 (D, SB);
ddnw #(.area(3.10026e-09), .perimeter(0.0002852), .dbv(0), .m(1), .par1(1), .xf_subext(0))
(* integer passed_mfactor = "m"; *)
 D0 (Sub, SB);
rnp1 #(.l(2.55e-05), .w(4.2e-07), .m(1), .par1(1))
(* integer passed_mfactor = "m"; *)
 R0 (SB, net20);

endmodule
// Library - HV_CELLS, Cell - ioh_pmbsab_15_10, View - schematic
// LAST TIME SAVED: Feb 25 05:55:56 2015
// NETLIST TIME: Feb  9 05:08:09 2024

`worklib HV_CELLS
`view schematic

`timescale 1ns / 1ps
(* cds_ams_schematic *)

module ioh_pmbsab_15_10 (B, D, G, S);
inout  B, D, G, S;
pmb #(.w(1.512e-05), .l(1e-06), .as(7.2576e-12), .ad(7.2576e-12), .ps(3.12e-05), .pd(3.12e-05), .nrs(0.0178571), .nrd(0.0178571), .m((1)*(1)), .par1((1)*(1)))
(* integer passed_mfactor = "m"; *)
 MPX (D, G, S, B);

endmodule
// Library - HV_CELLS, Cell - ioh_pmbsabhv_750, View - schematic
// LAST TIME SAVED: Feb 25 05:55:57 2015
// NETLIST TIME: Feb  9 05:08:09 2024

`worklib HV_CELLS
`view schematic

`timescale 1ns / 1ps
(* cds_ams_schematic *)

module ioh_pmbsabhv_750 (D, GSB, Sub);
inout  D, GSB, Sub;
wire [0:49] net20;
ioh_pmbsab_15_10 MP_1 (.D( net20[0] ), .B( GSB ), .G( GSB ), .S( GSB ));
ioh_pmbsab_15_10 MP_2 (.D( net20[1] ), .B( GSB ), .G( GSB ), .S( GSB ));
ioh_pmbsab_15_10 MP_3 (.D( net20[2] ), .B( GSB ), .G( GSB ), .S( GSB ));
ioh_pmbsab_15_10 MP_4 (.D( net20[3] ), .B( GSB ), .G( GSB ), .S( GSB ));
ioh_pmbsab_15_10 MP_5 (.D( net20[4] ), .B( GSB ), .G( GSB ), .S( GSB ));
ioh_pmbsab_15_10 MP_6 (.D( net20[5] ), .B( GSB ), .G( GSB ), .S( GSB ));
ioh_pmbsab_15_10 MP_7 (.D( net20[6] ), .B( GSB ), .G( GSB ), .S( GSB ));
ioh_pmbsab_15_10 MP_8 (.D( net20[7] ), .B( GSB ), .G( GSB ), .S( GSB ));
ioh_pmbsab_15_10 MP_9 (.D( net20[8] ), .B( GSB ), .G( GSB ), .S( GSB ));
ioh_pmbsab_15_10 MP_10 (.D( net20[9] ), .B( GSB ), .G( GSB ), .S( GSB ));
ioh_pmbsab_15_10 MP_11 (.D( net20[10] ), .B( GSB ), .G( GSB ), .S( GSB ));
ioh_pmbsab_15_10 MP_12 (.D( net20[11] ), .B( GSB ), .G( GSB ), .S( GSB ));
ioh_pmbsab_15_10 MP_13 (.D( net20[12] ), .B( GSB ), .G( GSB ), .S( GSB ));
ioh_pmbsab_15_10 MP_14 (.D( net20[13] ), .B( GSB ), .G( GSB ), .S( GSB ));
ioh_pmbsab_15_10 MP_15 (.D( net20[14] ), .B( GSB ), .G( GSB ), .S( GSB ));
ioh_pmbsab_15_10 MP_16 (.D( net20[15] ), .B( GSB ), .G( GSB ), .S( GSB ));
ioh_pmbsab_15_10 MP_17 (.D( net20[16] ), .B( GSB ), .G( GSB ), .S( GSB ));
ioh_pmbsab_15_10 MP_18 (.D( net20[17] ), .B( GSB ), .G( GSB ), .S( GSB ));
ioh_pmbsab_15_10 MP_19 (.D( net20[18] ), .B( GSB ), .G( GSB ), .S( GSB ));
ioh_pmbsab_15_10 MP_20 (.D( net20[19] ), .B( GSB ), .G( GSB ), .S( GSB ));
ioh_pmbsab_15_10 MP_21 (.D( net20[20] ), .B( GSB ), .G( GSB ), .S( GSB ));
ioh_pmbsab_15_10 MP_22 (.D( net20[21] ), .B( GSB ), .G( GSB ), .S( GSB ));
ioh_pmbsab_15_10 MP_23 (.D( net20[22] ), .B( GSB ), .G( GSB ), .S( GSB ));
ioh_pmbsab_15_10 MP_24 (.D( net20[23] ), .B( GSB ), .G( GSB ), .S( GSB ));
ioh_pmbsab_15_10 MP_25 (.D( net20[24] ), .B( GSB ), .G( GSB ), .S( GSB ));
ioh_pmbsab_15_10 MP_26 (.D( net20[25] ), .B( GSB ), .G( GSB ), .S( GSB ));
ioh_pmbsab_15_10 MP_27 (.D( net20[26] ), .B( GSB ), .G( GSB ), .S( GSB ));
ioh_pmbsab_15_10 MP_28 (.D( net20[27] ), .B( GSB ), .G( GSB ), .S( GSB ));
ioh_pmbsab_15_10 MP_29 (.D( net20[28] ), .B( GSB ), .G( GSB ), .S( GSB ));
ioh_pmbsab_15_10 MP_30 (.D( net20[29] ), .B( GSB ), .G( GSB ), .S( GSB ));
ioh_pmbsab_15_10 MP_31 (.D( net20[30] ), .B( GSB ), .G( GSB ), .S( GSB ));
ioh_pmbsab_15_10 MP_32 (.D( net20[31] ), .B( GSB ), .G( GSB ), .S( GSB ));
ioh_pmbsab_15_10 MP_33 (.D( net20[32] ), .B( GSB ), .G( GSB ), .S( GSB ));
ioh_pmbsab_15_10 MP_34 (.D( net20[33] ), .B( GSB ), .G( GSB ), .S( GSB ));
ioh_pmbsab_15_10 MP_35 (.D( net20[34] ), .B( GSB ), .G( GSB ), .S( GSB ));
ioh_pmbsab_15_10 MP_36 (.D( net20[35] ), .B( GSB ), .G( GSB ), .S( GSB ));
ioh_pmbsab_15_10 MP_37 (.D( net20[36] ), .B( GSB ), .G( GSB ), .S( GSB ));
ioh_pmbsab_15_10 MP_38 (.D( net20[37] ), .B( GSB ), .G( GSB ), .S( GSB ));
ioh_pmbsab_15_10 MP_39 (.D( net20[38] ), .B( GSB ), .G( GSB ), .S( GSB ));
ioh_pmbsab_15_10 MP_40 (.D( net20[39] ), .B( GSB ), .G( GSB ), .S( GSB ));
ioh_pmbsab_15_10 MP_41 (.D( net20[40] ), .B( GSB ), .G( GSB ), .S( GSB ));
ioh_pmbsab_15_10 MP_42 (.D( net20[41] ), .B( GSB ), .G( GSB ), .S( GSB ));
ioh_pmbsab_15_10 MP_43 (.D( net20[42] ), .B( GSB ), .G( GSB ), .S( GSB ));
ioh_pmbsab_15_10 MP_44 (.D( net20[43] ), .B( GSB ), .G( GSB ), .S( GSB ));
ioh_pmbsab_15_10 MP_45 (.D( net20[44] ), .B( GSB ), .G( GSB ), .S( GSB ));
ioh_pmbsab_15_10 MP_46 (.D( net20[45] ), .B( GSB ), .G( GSB ), .S( GSB ));
ioh_pmbsab_15_10 MP_47 (.D( net20[46] ), .B( GSB ), .G( GSB ), .S( GSB ));
ioh_pmbsab_15_10 MP_48 (.D( net20[47] ), .B( GSB ), .G( GSB ), .S( GSB ));
ioh_pmbsab_15_10 MP_49 (.D( net20[48] ), .B( GSB ), .G( GSB ), .S( GSB ));
ioh_pmbsab_15_10 MP_50 (.D( net20[49] ), .B( GSB ), .G( GSB ), .S( GSB ));
rdp_io #(.l(5.1e-07), .w(1.5e-05), .m(1), .par1(1), .xf_subext(0))
(* integer passed_mfactor = "m"; *)
 R0_1 (net20[0], D, GSB);
rdp_io #(.l(5.1e-07), .w(1.5e-05), .m(1), .par1(1), .xf_subext(0))
(* integer passed_mfactor = "m"; *)
 R0_2 (net20[1], D, GSB);
rdp_io #(.l(5.1e-07), .w(1.5e-05), .m(1), .par1(1), .xf_subext(0))
(* integer passed_mfactor = "m"; *)
 R0_3 (net20[2], D, GSB);
rdp_io #(.l(5.1e-07), .w(1.5e-05), .m(1), .par1(1), .xf_subext(0))
(* integer passed_mfactor = "m"; *)
 R0_4 (net20[3], D, GSB);
rdp_io #(.l(5.1e-07), .w(1.5e-05), .m(1), .par1(1), .xf_subext(0))
(* integer passed_mfactor = "m"; *)
 R0_5 (net20[4], D, GSB);
rdp_io #(.l(5.1e-07), .w(1.5e-05), .m(1), .par1(1), .xf_subext(0))
(* integer passed_mfactor = "m"; *)
 R0_6 (net20[5], D, GSB);
rdp_io #(.l(5.1e-07), .w(1.5e-05), .m(1), .par1(1), .xf_subext(0))
(* integer passed_mfactor = "m"; *)
 R0_7 (net20[6], D, GSB);
rdp_io #(.l(5.1e-07), .w(1.5e-05), .m(1), .par1(1), .xf_subext(0))
(* integer passed_mfactor = "m"; *)
 R0_8 (net20[7], D, GSB);
rdp_io #(.l(5.1e-07), .w(1.5e-05), .m(1), .par1(1), .xf_subext(0))
(* integer passed_mfactor = "m"; *)
 R0_9 (net20[8], D, GSB);
rdp_io #(.l(5.1e-07), .w(1.5e-05), .m(1), .par1(1), .xf_subext(0))
(* integer passed_mfactor = "m"; *)
 R0_10 (net20[9], D, GSB);
rdp_io #(.l(5.1e-07), .w(1.5e-05), .m(1), .par1(1), .xf_subext(0))
(* integer passed_mfactor = "m"; *)
 R0_11 (net20[10], D, GSB);
rdp_io #(.l(5.1e-07), .w(1.5e-05), .m(1), .par1(1), .xf_subext(0))
(* integer passed_mfactor = "m"; *)
 R0_12 (net20[11], D, GSB);
rdp_io #(.l(5.1e-07), .w(1.5e-05), .m(1), .par1(1), .xf_subext(0))
(* integer passed_mfactor = "m"; *)
 R0_13 (net20[12], D, GSB);
rdp_io #(.l(5.1e-07), .w(1.5e-05), .m(1), .par1(1), .xf_subext(0))
(* integer passed_mfactor = "m"; *)
 R0_14 (net20[13], D, GSB);
rdp_io #(.l(5.1e-07), .w(1.5e-05), .m(1), .par1(1), .xf_subext(0))
(* integer passed_mfactor = "m"; *)
 R0_15 (net20[14], D, GSB);
rdp_io #(.l(5.1e-07), .w(1.5e-05), .m(1), .par1(1), .xf_subext(0))
(* integer passed_mfactor = "m"; *)
 R0_16 (net20[15], D, GSB);
rdp_io #(.l(5.1e-07), .w(1.5e-05), .m(1), .par1(1), .xf_subext(0))
(* integer passed_mfactor = "m"; *)
 R0_17 (net20[16], D, GSB);
rdp_io #(.l(5.1e-07), .w(1.5e-05), .m(1), .par1(1), .xf_subext(0))
(* integer passed_mfactor = "m"; *)
 R0_18 (net20[17], D, GSB);
rdp_io #(.l(5.1e-07), .w(1.5e-05), .m(1), .par1(1), .xf_subext(0))
(* integer passed_mfactor = "m"; *)
 R0_19 (net20[18], D, GSB);
rdp_io #(.l(5.1e-07), .w(1.5e-05), .m(1), .par1(1), .xf_subext(0))
(* integer passed_mfactor = "m"; *)
 R0_20 (net20[19], D, GSB);
rdp_io #(.l(5.1e-07), .w(1.5e-05), .m(1), .par1(1), .xf_subext(0))
(* integer passed_mfactor = "m"; *)
 R0_21 (net20[20], D, GSB);
rdp_io #(.l(5.1e-07), .w(1.5e-05), .m(1), .par1(1), .xf_subext(0))
(* integer passed_mfactor = "m"; *)
 R0_22 (net20[21], D, GSB);
rdp_io #(.l(5.1e-07), .w(1.5e-05), .m(1), .par1(1), .xf_subext(0))
(* integer passed_mfactor = "m"; *)
 R0_23 (net20[22], D, GSB);
rdp_io #(.l(5.1e-07), .w(1.5e-05), .m(1), .par1(1), .xf_subext(0))
(* integer passed_mfactor = "m"; *)
 R0_24 (net20[23], D, GSB);
rdp_io #(.l(5.1e-07), .w(1.5e-05), .m(1), .par1(1), .xf_subext(0))
(* integer passed_mfactor = "m"; *)
 R0_25 (net20[24], D, GSB);
rdp_io #(.l(5.1e-07), .w(1.5e-05), .m(1), .par1(1), .xf_subext(0))
(* integer passed_mfactor = "m"; *)
 R0_26 (net20[25], D, GSB);
rdp_io #(.l(5.1e-07), .w(1.5e-05), .m(1), .par1(1), .xf_subext(0))
(* integer passed_mfactor = "m"; *)
 R0_27 (net20[26], D, GSB);
rdp_io #(.l(5.1e-07), .w(1.5e-05), .m(1), .par1(1), .xf_subext(0))
(* integer passed_mfactor = "m"; *)
 R0_28 (net20[27], D, GSB);
rdp_io #(.l(5.1e-07), .w(1.5e-05), .m(1), .par1(1), .xf_subext(0))
(* integer passed_mfactor = "m"; *)
 R0_29 (net20[28], D, GSB);
rdp_io #(.l(5.1e-07), .w(1.5e-05), .m(1), .par1(1), .xf_subext(0))
(* integer passed_mfactor = "m"; *)
 R0_30 (net20[29], D, GSB);
rdp_io #(.l(5.1e-07), .w(1.5e-05), .m(1), .par1(1), .xf_subext(0))
(* integer passed_mfactor = "m"; *)
 R0_31 (net20[30], D, GSB);
rdp_io #(.l(5.1e-07), .w(1.5e-05), .m(1), .par1(1), .xf_subext(0))
(* integer passed_mfactor = "m"; *)
 R0_32 (net20[31], D, GSB);
rdp_io #(.l(5.1e-07), .w(1.5e-05), .m(1), .par1(1), .xf_subext(0))
(* integer passed_mfactor = "m"; *)
 R0_33 (net20[32], D, GSB);
rdp_io #(.l(5.1e-07), .w(1.5e-05), .m(1), .par1(1), .xf_subext(0))
(* integer passed_mfactor = "m"; *)
 R0_34 (net20[33], D, GSB);
rdp_io #(.l(5.1e-07), .w(1.5e-05), .m(1), .par1(1), .xf_subext(0))
(* integer passed_mfactor = "m"; *)
 R0_35 (net20[34], D, GSB);
rdp_io #(.l(5.1e-07), .w(1.5e-05), .m(1), .par1(1), .xf_subext(0))
(* integer passed_mfactor = "m"; *)
 R0_36 (net20[35], D, GSB);
rdp_io #(.l(5.1e-07), .w(1.5e-05), .m(1), .par1(1), .xf_subext(0))
(* integer passed_mfactor = "m"; *)
 R0_37 (net20[36], D, GSB);
rdp_io #(.l(5.1e-07), .w(1.5e-05), .m(1), .par1(1), .xf_subext(0))
(* integer passed_mfactor = "m"; *)
 R0_38 (net20[37], D, GSB);
rdp_io #(.l(5.1e-07), .w(1.5e-05), .m(1), .par1(1), .xf_subext(0))
(* integer passed_mfactor = "m"; *)
 R0_39 (net20[38], D, GSB);
rdp_io #(.l(5.1e-07), .w(1.5e-05), .m(1), .par1(1), .xf_subext(0))
(* integer passed_mfactor = "m"; *)
 R0_40 (net20[39], D, GSB);
rdp_io #(.l(5.1e-07), .w(1.5e-05), .m(1), .par1(1), .xf_subext(0))
(* integer passed_mfactor = "m"; *)
 R0_41 (net20[40], D, GSB);
rdp_io #(.l(5.1e-07), .w(1.5e-05), .m(1), .par1(1), .xf_subext(0))
(* integer passed_mfactor = "m"; *)
 R0_42 (net20[41], D, GSB);
rdp_io #(.l(5.1e-07), .w(1.5e-05), .m(1), .par1(1), .xf_subext(0))
(* integer passed_mfactor = "m"; *)
 R0_43 (net20[42], D, GSB);
rdp_io #(.l(5.1e-07), .w(1.5e-05), .m(1), .par1(1), .xf_subext(0))
(* integer passed_mfactor = "m"; *)
 R0_44 (net20[43], D, GSB);
rdp_io #(.l(5.1e-07), .w(1.5e-05), .m(1), .par1(1), .xf_subext(0))
(* integer passed_mfactor = "m"; *)
 R0_45 (net20[44], D, GSB);
rdp_io #(.l(5.1e-07), .w(1.5e-05), .m(1), .par1(1), .xf_subext(0))
(* integer passed_mfactor = "m"; *)
 R0_46 (net20[45], D, GSB);
rdp_io #(.l(5.1e-07), .w(1.5e-05), .m(1), .par1(1), .xf_subext(0))
(* integer passed_mfactor = "m"; *)
 R0_47 (net20[46], D, GSB);
rdp_io #(.l(5.1e-07), .w(1.5e-05), .m(1), .par1(1), .xf_subext(0))
(* integer passed_mfactor = "m"; *)
 R0_48 (net20[47], D, GSB);
rdp_io #(.l(5.1e-07), .w(1.5e-05), .m(1), .par1(1), .xf_subext(0))
(* integer passed_mfactor = "m"; *)
 R0_49 (net20[48], D, GSB);
rdp_io #(.l(5.1e-07), .w(1.5e-05), .m(1), .par1(1), .xf_subext(0))
(* integer passed_mfactor = "m"; *)
 R0_50 (net20[49], D, GSB);
dphnw #(.area(4.95062e-12), .perimeter(6.6e-07), .dbv(0), .m(1), .par1(1))
(* integer passed_mfactor = "m"; *)
 D0_1 (D, GSB);
dphnw #(.area(4.95062e-12), .perimeter(6.6e-07), .dbv(0), .m(1), .par1(1))
(* integer passed_mfactor = "m"; *)
 D0_2 (D, GSB);
dphnw #(.area(4.95062e-12), .perimeter(6.6e-07), .dbv(0), .m(1), .par1(1))
(* integer passed_mfactor = "m"; *)
 D0_3 (D, GSB);
dphnw #(.area(4.95062e-12), .perimeter(6.6e-07), .dbv(0), .m(1), .par1(1))
(* integer passed_mfactor = "m"; *)
 D0_4 (D, GSB);
dphnw #(.area(4.95062e-12), .perimeter(6.6e-07), .dbv(0), .m(1), .par1(1))
(* integer passed_mfactor = "m"; *)
 D0_5 (D, GSB);
dphnw #(.area(4.95062e-12), .perimeter(6.6e-07), .dbv(0), .m(1), .par1(1))
(* integer passed_mfactor = "m"; *)
 D0_6 (D, GSB);
dphnw #(.area(4.95062e-12), .perimeter(6.6e-07), .dbv(0), .m(1), .par1(1))
(* integer passed_mfactor = "m"; *)
 D0_7 (D, GSB);
dphnw #(.area(4.95062e-12), .perimeter(6.6e-07), .dbv(0), .m(1), .par1(1))
(* integer passed_mfactor = "m"; *)
 D0_8 (D, GSB);
dphnw #(.area(4.95062e-12), .perimeter(6.6e-07), .dbv(0), .m(1), .par1(1))
(* integer passed_mfactor = "m"; *)
 D0_9 (D, GSB);
dphnw #(.area(4.95062e-12), .perimeter(6.6e-07), .dbv(0), .m(1), .par1(1))
(* integer passed_mfactor = "m"; *)
 D0_10 (D, GSB);
dphnw #(.area(4.95062e-12), .perimeter(6.6e-07), .dbv(0), .m(1), .par1(1))
(* integer passed_mfactor = "m"; *)
 D0_11 (D, GSB);
dphnw #(.area(4.95062e-12), .perimeter(6.6e-07), .dbv(0), .m(1), .par1(1))
(* integer passed_mfactor = "m"; *)
 D0_12 (D, GSB);
dphnw #(.area(4.95062e-12), .perimeter(6.6e-07), .dbv(0), .m(1), .par1(1))
(* integer passed_mfactor = "m"; *)
 D0_13 (D, GSB);
dphnw #(.area(4.95062e-12), .perimeter(6.6e-07), .dbv(0), .m(1), .par1(1))
(* integer passed_mfactor = "m"; *)
 D0_14 (D, GSB);
dphnw #(.area(4.95062e-12), .perimeter(6.6e-07), .dbv(0), .m(1), .par1(1))
(* integer passed_mfactor = "m"; *)
 D0_15 (D, GSB);
dphnw #(.area(4.95062e-12), .perimeter(6.6e-07), .dbv(0), .m(1), .par1(1))
(* integer passed_mfactor = "m"; *)
 D0_16 (D, GSB);
dphnw #(.area(4.95062e-12), .perimeter(6.6e-07), .dbv(0), .m(1), .par1(1))
(* integer passed_mfactor = "m"; *)
 D0_17 (D, GSB);
dphnw #(.area(4.95062e-12), .perimeter(6.6e-07), .dbv(0), .m(1), .par1(1))
(* integer passed_mfactor = "m"; *)
 D0_18 (D, GSB);
dphnw #(.area(4.95062e-12), .perimeter(6.6e-07), .dbv(0), .m(1), .par1(1))
(* integer passed_mfactor = "m"; *)
 D0_19 (D, GSB);
dphnw #(.area(4.95062e-12), .perimeter(6.6e-07), .dbv(0), .m(1), .par1(1))
(* integer passed_mfactor = "m"; *)
 D0_20 (D, GSB);
dphnw #(.area(4.95062e-12), .perimeter(6.6e-07), .dbv(0), .m(1), .par1(1))
(* integer passed_mfactor = "m"; *)
 D0_21 (D, GSB);
dphnw #(.area(4.95062e-12), .perimeter(6.6e-07), .dbv(0), .m(1), .par1(1))
(* integer passed_mfactor = "m"; *)
 D0_22 (D, GSB);
dphnw #(.area(4.95062e-12), .perimeter(6.6e-07), .dbv(0), .m(1), .par1(1))
(* integer passed_mfactor = "m"; *)
 D0_23 (D, GSB);
dphnw #(.area(4.95062e-12), .perimeter(6.6e-07), .dbv(0), .m(1), .par1(1))
(* integer passed_mfactor = "m"; *)
 D0_24 (D, GSB);
dphnw #(.area(4.95062e-12), .perimeter(6.6e-07), .dbv(0), .m(1), .par1(1))
(* integer passed_mfactor = "m"; *)
 D0_25 (D, GSB);
dphnw #(.area(4.95062e-12), .perimeter(6.6e-07), .dbv(0), .m(1), .par1(1))
(* integer passed_mfactor = "m"; *)
 D0_26 (D, GSB);
dphnw #(.area(4.95062e-12), .perimeter(6.6e-07), .dbv(0), .m(1), .par1(1))
(* integer passed_mfactor = "m"; *)
 D0_27 (D, GSB);
dphnw #(.area(4.95062e-12), .perimeter(6.6e-07), .dbv(0), .m(1), .par1(1))
(* integer passed_mfactor = "m"; *)
 D0_28 (D, GSB);
dphnw #(.area(4.95062e-12), .perimeter(6.6e-07), .dbv(0), .m(1), .par1(1))
(* integer passed_mfactor = "m"; *)
 D0_29 (D, GSB);
dphnw #(.area(4.95062e-12), .perimeter(6.6e-07), .dbv(0), .m(1), .par1(1))
(* integer passed_mfactor = "m"; *)
 D0_30 (D, GSB);
dphnw #(.area(4.95062e-12), .perimeter(6.6e-07), .dbv(0), .m(1), .par1(1))
(* integer passed_mfactor = "m"; *)
 D0_31 (D, GSB);
dphnw #(.area(4.95062e-12), .perimeter(6.6e-07), .dbv(0), .m(1), .par1(1))
(* integer passed_mfactor = "m"; *)
 D0_32 (D, GSB);
dphnw #(.area(4.95062e-12), .perimeter(6.6e-07), .dbv(0), .m(1), .par1(1))
(* integer passed_mfactor = "m"; *)
 D0_33 (D, GSB);
dphnw #(.area(4.95062e-12), .perimeter(6.6e-07), .dbv(0), .m(1), .par1(1))
(* integer passed_mfactor = "m"; *)
 D0_34 (D, GSB);
dphnw #(.area(4.95062e-12), .perimeter(6.6e-07), .dbv(0), .m(1), .par1(1))
(* integer passed_mfactor = "m"; *)
 D0_35 (D, GSB);
dphnw #(.area(4.95062e-12), .perimeter(6.6e-07), .dbv(0), .m(1), .par1(1))
(* integer passed_mfactor = "m"; *)
 D0_36 (D, GSB);
dphnw #(.area(4.95062e-12), .perimeter(6.6e-07), .dbv(0), .m(1), .par1(1))
(* integer passed_mfactor = "m"; *)
 D0_37 (D, GSB);
dphnw #(.area(4.95062e-12), .perimeter(6.6e-07), .dbv(0), .m(1), .par1(1))
(* integer passed_mfactor = "m"; *)
 D0_38 (D, GSB);
dphnw #(.area(4.95062e-12), .perimeter(6.6e-07), .dbv(0), .m(1), .par1(1))
(* integer passed_mfactor = "m"; *)
 D0_39 (D, GSB);
dphnw #(.area(4.95062e-12), .perimeter(6.6e-07), .dbv(0), .m(1), .par1(1))
(* integer passed_mfactor = "m"; *)
 D0_40 (D, GSB);
dphnw #(.area(4.95062e-12), .perimeter(6.6e-07), .dbv(0), .m(1), .par1(1))
(* integer passed_mfactor = "m"; *)
 D0_41 (D, GSB);
dphnw #(.area(4.95062e-12), .perimeter(6.6e-07), .dbv(0), .m(1), .par1(1))
(* integer passed_mfactor = "m"; *)
 D0_42 (D, GSB);
dphnw #(.area(4.95062e-12), .perimeter(6.6e-07), .dbv(0), .m(1), .par1(1))
(* integer passed_mfactor = "m"; *)
 D0_43 (D, GSB);
dphnw #(.area(4.95062e-12), .perimeter(6.6e-07), .dbv(0), .m(1), .par1(1))
(* integer passed_mfactor = "m"; *)
 D0_44 (D, GSB);
dphnw #(.area(4.95062e-12), .perimeter(6.6e-07), .dbv(0), .m(1), .par1(1))
(* integer passed_mfactor = "m"; *)
 D0_45 (D, GSB);
dphnw #(.area(4.95062e-12), .perimeter(6.6e-07), .dbv(0), .m(1), .par1(1))
(* integer passed_mfactor = "m"; *)
 D0_46 (D, GSB);
dphnw #(.area(4.95062e-12), .perimeter(6.6e-07), .dbv(0), .m(1), .par1(1))
(* integer passed_mfactor = "m"; *)
 D0_47 (D, GSB);
dphnw #(.area(4.95062e-12), .perimeter(6.6e-07), .dbv(0), .m(1), .par1(1))
(* integer passed_mfactor = "m"; *)
 D0_48 (D, GSB);
dphnw #(.area(4.95062e-12), .perimeter(6.6e-07), .dbv(0), .m(1), .par1(1))
(* integer passed_mfactor = "m"; *)
 D0_49 (D, GSB);
dphnw #(.area(4.95062e-12), .perimeter(6.6e-07), .dbv(0), .m(1), .par1(1))
(* integer passed_mfactor = "m"; *)
 D0_50 (D, GSB);
ddnw #(.area(3.03711e-09), .perimeter(0.000284), .dbv(0), .m(1), .par1(1), .xf_subext(0))
(* integer passed_mfactor = "m"; *)
 D1 (Sub, GSB);

endmodule
// Library - HV_CELLS, Cell - ioh_c5pk, View - schematic
// LAST TIME SAVED: Feb 25 05:56:12 2015
// NETLIST TIME: Feb  9 05:08:09 2024

`worklib HV_CELLS
`view schematic

`timescale 1ns / 1ps
(* cds_ams_schematic *)

module ioh_c5pk (A_l, K_h, Sub);
inout  A_l, K_h, Sub;
wire net30;
wire net26;
wire net23;
wire net20;
ioh_pe3isabhv_1050gcr I5 (.Sub( Sub ), .SB( net30 ), .D( A_l ));
ioh_pmbsabhv_750 I3 (.Sub( Sub ), .D( net23 ), .GSB( net26 ));
ioh_pmbsabhv_750 I4 (.Sub( Sub ), .D( net30 ), .GSB( net23 ));
ioh_pmbsabhv_750 I2 (.Sub( Sub ), .D( net26 ), .GSB( net20 ));
ioh_pmbsabhv_750 I1 (.Sub( Sub ), .D( net20 ), .GSB( K_h ));

endmodule
// Library - HV_CELLS, Cell - HVD4SJD1R5PKFs, View - schematic
// LAST TIME SAVED: Feb 25 05:55:34 2015
// NETLIST TIME: Feb  9 05:08:09 2024

`worklib HV_CELLS
`view schematic

`timescale 1ns / 1ps
(* cds_ams_schematic *)

module HVD4SJD1R5PKFs (GNDO, IGND, PAD);
inout  GNDO, IGND, PAD;
wire Trig_0;
ioh_iscrd2_4x100 I10 (.Gp( Trig_0 ), .Sub( GNDO ), .A( PAD ), .Gn( PAD ), .K( IGND ));
ioh_dhpw_2x100_stack3 I9 (.A_l( IGND ), .Sub( GNDO ), .K_h( PAD ));
ioh_c5pk I11 (.Sub( GNDO ), .K_h( PAD ), .A_l( Trig_0 ));
rpp1s #(.l(1.6e-05), .w(0.0001), .m(1), .par1(1))
(* integer passed_mfactor = "m"; *)
 R4 (IGND, Trig_0);

endmodule
// Library - HV_CELLS, Cell - ioh_dhpw_2x100, View - schematic
// LAST TIME SAVED: Feb 25 05:55:51 2015
// NETLIST TIME: Feb  9 05:08:09 2024

`worklib HV_CELLS
`view schematic

`timescale 1ns / 1ps
(* cds_ams_schematic *)

module ioh_dhpw_2x100 (A, K, Sub);
inout  A, K, Sub;
ddnw #(.area(3.37852e-09), .perimeter(0.0002844), .dbv(0), .m(1), .par1(1), .xf_subext(0))
(* integer passed_mfactor = "m"; *)
 D0 (Sub, K);
dhpw #(.area(3.87893e-10), .perimeter(0.000207812), .dbv(0), .m(2), .par1(2))
(* integer passed_mfactor = "m"; *)
 D1 (A, K);

endmodule
// Library - HV_CELLS, Cell - ioh_dhpw_2x100_stack3, View - schematic
// LAST TIME SAVED: Feb 25 05:55:51 2015
// NETLIST TIME: Feb  9 05:08:09 2024

`worklib HV_CELLS
`view schematic

`timescale 1ns / 1ps
(* cds_ams_schematic *)

module ioh_dhpw_2x100_stack3 (A_l, K_h, Sub);
inout  A_l, K_h, Sub;
wire net20;
wire net14;
ioh_dhpw_2x100 I0 (.A( A_l ), .K( net20 ), .Sub( Sub ));
ioh_dhpw_2x100 I2 (.A( net14 ), .K( K_h ), .Sub( Sub ));
ioh_dhpw_2x100 I1 (.A( net20 ), .K( net14 ), .Sub( Sub ));

endmodule
// Library - HV_CELLS, Cell - ioh_pmbsab_40_10, View - schematic
// LAST TIME SAVED: Feb 25 05:55:57 2015
// NETLIST TIME: Feb  9 05:08:09 2024

`worklib HV_CELLS
`view schematic

`timescale 1ns / 1ps
(* cds_ams_schematic *)

module ioh_pmbsab_40_10 (B, D, G, S);
inout  B, D, G, S;
pmb #(.w(4.012e-05), .l(1e-06), .as(1.92576e-11), .ad(1.92576e-11), .ps(8.12e-05), .pd(8.12e-05), .nrs(0.00672981), .nrd(0.00672981), .m((1)*(1)), .par1((1)*(1)))
(* integer passed_mfactor = "m"; *)
 MPX (D, G, S, B);

endmodule
// Library - HV_CELLS, Cell - ioh_pmbsabhv_2000, View - schematic
// LAST TIME SAVED: Feb 25 05:55:57 2015
// NETLIST TIME: Feb  9 05:08:09 2024

`worklib HV_CELLS
`view schematic

`timescale 1ns / 1ps
(* cds_ams_schematic *)

module ioh_pmbsabhv_2000 (D, GSB, Sub);
inout  D, GSB, Sub;
wire [0:49] net20;
ioh_pmbsab_40_10 MP_1 (.D( net20[0] ), .B( GSB ), .G( GSB ), .S( GSB ));
ioh_pmbsab_40_10 MP_2 (.D( net20[1] ), .B( GSB ), .G( GSB ), .S( GSB ));
ioh_pmbsab_40_10 MP_3 (.D( net20[2] ), .B( GSB ), .G( GSB ), .S( GSB ));
ioh_pmbsab_40_10 MP_4 (.D( net20[3] ), .B( GSB ), .G( GSB ), .S( GSB ));
ioh_pmbsab_40_10 MP_5 (.D( net20[4] ), .B( GSB ), .G( GSB ), .S( GSB ));
ioh_pmbsab_40_10 MP_6 (.D( net20[5] ), .B( GSB ), .G( GSB ), .S( GSB ));
ioh_pmbsab_40_10 MP_7 (.D( net20[6] ), .B( GSB ), .G( GSB ), .S( GSB ));
ioh_pmbsab_40_10 MP_8 (.D( net20[7] ), .B( GSB ), .G( GSB ), .S( GSB ));
ioh_pmbsab_40_10 MP_9 (.D( net20[8] ), .B( GSB ), .G( GSB ), .S( GSB ));
ioh_pmbsab_40_10 MP_10 (.D( net20[9] ), .B( GSB ), .G( GSB ), .S( GSB ));
ioh_pmbsab_40_10 MP_11 (.D( net20[10] ), .B( GSB ), .G( GSB ), .S( GSB ));
ioh_pmbsab_40_10 MP_12 (.D( net20[11] ), .B( GSB ), .G( GSB ), .S( GSB ));
ioh_pmbsab_40_10 MP_13 (.D( net20[12] ), .B( GSB ), .G( GSB ), .S( GSB ));
ioh_pmbsab_40_10 MP_14 (.D( net20[13] ), .B( GSB ), .G( GSB ), .S( GSB ));
ioh_pmbsab_40_10 MP_15 (.D( net20[14] ), .B( GSB ), .G( GSB ), .S( GSB ));
ioh_pmbsab_40_10 MP_16 (.D( net20[15] ), .B( GSB ), .G( GSB ), .S( GSB ));
ioh_pmbsab_40_10 MP_17 (.D( net20[16] ), .B( GSB ), .G( GSB ), .S( GSB ));
ioh_pmbsab_40_10 MP_18 (.D( net20[17] ), .B( GSB ), .G( GSB ), .S( GSB ));
ioh_pmbsab_40_10 MP_19 (.D( net20[18] ), .B( GSB ), .G( GSB ), .S( GSB ));
ioh_pmbsab_40_10 MP_20 (.D( net20[19] ), .B( GSB ), .G( GSB ), .S( GSB ));
ioh_pmbsab_40_10 MP_21 (.D( net20[20] ), .B( GSB ), .G( GSB ), .S( GSB ));
ioh_pmbsab_40_10 MP_22 (.D( net20[21] ), .B( GSB ), .G( GSB ), .S( GSB ));
ioh_pmbsab_40_10 MP_23 (.D( net20[22] ), .B( GSB ), .G( GSB ), .S( GSB ));
ioh_pmbsab_40_10 MP_24 (.D( net20[23] ), .B( GSB ), .G( GSB ), .S( GSB ));
ioh_pmbsab_40_10 MP_25 (.D( net20[24] ), .B( GSB ), .G( GSB ), .S( GSB ));
ioh_pmbsab_40_10 MP_26 (.D( net20[25] ), .B( GSB ), .G( GSB ), .S( GSB ));
ioh_pmbsab_40_10 MP_27 (.D( net20[26] ), .B( GSB ), .G( GSB ), .S( GSB ));
ioh_pmbsab_40_10 MP_28 (.D( net20[27] ), .B( GSB ), .G( GSB ), .S( GSB ));
ioh_pmbsab_40_10 MP_29 (.D( net20[28] ), .B( GSB ), .G( GSB ), .S( GSB ));
ioh_pmbsab_40_10 MP_30 (.D( net20[29] ), .B( GSB ), .G( GSB ), .S( GSB ));
ioh_pmbsab_40_10 MP_31 (.D( net20[30] ), .B( GSB ), .G( GSB ), .S( GSB ));
ioh_pmbsab_40_10 MP_32 (.D( net20[31] ), .B( GSB ), .G( GSB ), .S( GSB ));
ioh_pmbsab_40_10 MP_33 (.D( net20[32] ), .B( GSB ), .G( GSB ), .S( GSB ));
ioh_pmbsab_40_10 MP_34 (.D( net20[33] ), .B( GSB ), .G( GSB ), .S( GSB ));
ioh_pmbsab_40_10 MP_35 (.D( net20[34] ), .B( GSB ), .G( GSB ), .S( GSB ));
ioh_pmbsab_40_10 MP_36 (.D( net20[35] ), .B( GSB ), .G( GSB ), .S( GSB ));
ioh_pmbsab_40_10 MP_37 (.D( net20[36] ), .B( GSB ), .G( GSB ), .S( GSB ));
ioh_pmbsab_40_10 MP_38 (.D( net20[37] ), .B( GSB ), .G( GSB ), .S( GSB ));
ioh_pmbsab_40_10 MP_39 (.D( net20[38] ), .B( GSB ), .G( GSB ), .S( GSB ));
ioh_pmbsab_40_10 MP_40 (.D( net20[39] ), .B( GSB ), .G( GSB ), .S( GSB ));
ioh_pmbsab_40_10 MP_41 (.D( net20[40] ), .B( GSB ), .G( GSB ), .S( GSB ));
ioh_pmbsab_40_10 MP_42 (.D( net20[41] ), .B( GSB ), .G( GSB ), .S( GSB ));
ioh_pmbsab_40_10 MP_43 (.D( net20[42] ), .B( GSB ), .G( GSB ), .S( GSB ));
ioh_pmbsab_40_10 MP_44 (.D( net20[43] ), .B( GSB ), .G( GSB ), .S( GSB ));
ioh_pmbsab_40_10 MP_45 (.D( net20[44] ), .B( GSB ), .G( GSB ), .S( GSB ));
ioh_pmbsab_40_10 MP_46 (.D( net20[45] ), .B( GSB ), .G( GSB ), .S( GSB ));
ioh_pmbsab_40_10 MP_47 (.D( net20[46] ), .B( GSB ), .G( GSB ), .S( GSB ));
ioh_pmbsab_40_10 MP_48 (.D( net20[47] ), .B( GSB ), .G( GSB ), .S( GSB ));
ioh_pmbsab_40_10 MP_49 (.D( net20[48] ), .B( GSB ), .G( GSB ), .S( GSB ));
ioh_pmbsab_40_10 MP_50 (.D( net20[49] ), .B( GSB ), .G( GSB ), .S( GSB ));
rdp_io #(.l(5.1e-07), .w(4e-05), .m(1), .par1(1), .xf_subext(0))
(* integer passed_mfactor = "m"; *)
 R0_1 (net20[0], D, GSB);
rdp_io #(.l(5.1e-07), .w(4e-05), .m(1), .par1(1), .xf_subext(0))
(* integer passed_mfactor = "m"; *)
 R0_2 (net20[1], D, GSB);
rdp_io #(.l(5.1e-07), .w(4e-05), .m(1), .par1(1), .xf_subext(0))
(* integer passed_mfactor = "m"; *)
 R0_3 (net20[2], D, GSB);
rdp_io #(.l(5.1e-07), .w(4e-05), .m(1), .par1(1), .xf_subext(0))
(* integer passed_mfactor = "m"; *)
 R0_4 (net20[3], D, GSB);
rdp_io #(.l(5.1e-07), .w(4e-05), .m(1), .par1(1), .xf_subext(0))
(* integer passed_mfactor = "m"; *)
 R0_5 (net20[4], D, GSB);
rdp_io #(.l(5.1e-07), .w(4e-05), .m(1), .par1(1), .xf_subext(0))
(* integer passed_mfactor = "m"; *)
 R0_6 (net20[5], D, GSB);
rdp_io #(.l(5.1e-07), .w(4e-05), .m(1), .par1(1), .xf_subext(0))
(* integer passed_mfactor = "m"; *)
 R0_7 (net20[6], D, GSB);
rdp_io #(.l(5.1e-07), .w(4e-05), .m(1), .par1(1), .xf_subext(0))
(* integer passed_mfactor = "m"; *)
 R0_8 (net20[7], D, GSB);
rdp_io #(.l(5.1e-07), .w(4e-05), .m(1), .par1(1), .xf_subext(0))
(* integer passed_mfactor = "m"; *)
 R0_9 (net20[8], D, GSB);
rdp_io #(.l(5.1e-07), .w(4e-05), .m(1), .par1(1), .xf_subext(0))
(* integer passed_mfactor = "m"; *)
 R0_10 (net20[9], D, GSB);
rdp_io #(.l(5.1e-07), .w(4e-05), .m(1), .par1(1), .xf_subext(0))
(* integer passed_mfactor = "m"; *)
 R0_11 (net20[10], D, GSB);
rdp_io #(.l(5.1e-07), .w(4e-05), .m(1), .par1(1), .xf_subext(0))
(* integer passed_mfactor = "m"; *)
 R0_12 (net20[11], D, GSB);
rdp_io #(.l(5.1e-07), .w(4e-05), .m(1), .par1(1), .xf_subext(0))
(* integer passed_mfactor = "m"; *)
 R0_13 (net20[12], D, GSB);
rdp_io #(.l(5.1e-07), .w(4e-05), .m(1), .par1(1), .xf_subext(0))
(* integer passed_mfactor = "m"; *)
 R0_14 (net20[13], D, GSB);
rdp_io #(.l(5.1e-07), .w(4e-05), .m(1), .par1(1), .xf_subext(0))
(* integer passed_mfactor = "m"; *)
 R0_15 (net20[14], D, GSB);
rdp_io #(.l(5.1e-07), .w(4e-05), .m(1), .par1(1), .xf_subext(0))
(* integer passed_mfactor = "m"; *)
 R0_16 (net20[15], D, GSB);
rdp_io #(.l(5.1e-07), .w(4e-05), .m(1), .par1(1), .xf_subext(0))
(* integer passed_mfactor = "m"; *)
 R0_17 (net20[16], D, GSB);
rdp_io #(.l(5.1e-07), .w(4e-05), .m(1), .par1(1), .xf_subext(0))
(* integer passed_mfactor = "m"; *)
 R0_18 (net20[17], D, GSB);
rdp_io #(.l(5.1e-07), .w(4e-05), .m(1), .par1(1), .xf_subext(0))
(* integer passed_mfactor = "m"; *)
 R0_19 (net20[18], D, GSB);
rdp_io #(.l(5.1e-07), .w(4e-05), .m(1), .par1(1), .xf_subext(0))
(* integer passed_mfactor = "m"; *)
 R0_20 (net20[19], D, GSB);
rdp_io #(.l(5.1e-07), .w(4e-05), .m(1), .par1(1), .xf_subext(0))
(* integer passed_mfactor = "m"; *)
 R0_21 (net20[20], D, GSB);
rdp_io #(.l(5.1e-07), .w(4e-05), .m(1), .par1(1), .xf_subext(0))
(* integer passed_mfactor = "m"; *)
 R0_22 (net20[21], D, GSB);
rdp_io #(.l(5.1e-07), .w(4e-05), .m(1), .par1(1), .xf_subext(0))
(* integer passed_mfactor = "m"; *)
 R0_23 (net20[22], D, GSB);
rdp_io #(.l(5.1e-07), .w(4e-05), .m(1), .par1(1), .xf_subext(0))
(* integer passed_mfactor = "m"; *)
 R0_24 (net20[23], D, GSB);
rdp_io #(.l(5.1e-07), .w(4e-05), .m(1), .par1(1), .xf_subext(0))
(* integer passed_mfactor = "m"; *)
 R0_25 (net20[24], D, GSB);
rdp_io #(.l(5.1e-07), .w(4e-05), .m(1), .par1(1), .xf_subext(0))
(* integer passed_mfactor = "m"; *)
 R0_26 (net20[25], D, GSB);
rdp_io #(.l(5.1e-07), .w(4e-05), .m(1), .par1(1), .xf_subext(0))
(* integer passed_mfactor = "m"; *)
 R0_27 (net20[26], D, GSB);
rdp_io #(.l(5.1e-07), .w(4e-05), .m(1), .par1(1), .xf_subext(0))
(* integer passed_mfactor = "m"; *)
 R0_28 (net20[27], D, GSB);
rdp_io #(.l(5.1e-07), .w(4e-05), .m(1), .par1(1), .xf_subext(0))
(* integer passed_mfactor = "m"; *)
 R0_29 (net20[28], D, GSB);
rdp_io #(.l(5.1e-07), .w(4e-05), .m(1), .par1(1), .xf_subext(0))
(* integer passed_mfactor = "m"; *)
 R0_30 (net20[29], D, GSB);
rdp_io #(.l(5.1e-07), .w(4e-05), .m(1), .par1(1), .xf_subext(0))
(* integer passed_mfactor = "m"; *)
 R0_31 (net20[30], D, GSB);
rdp_io #(.l(5.1e-07), .w(4e-05), .m(1), .par1(1), .xf_subext(0))
(* integer passed_mfactor = "m"; *)
 R0_32 (net20[31], D, GSB);
rdp_io #(.l(5.1e-07), .w(4e-05), .m(1), .par1(1), .xf_subext(0))
(* integer passed_mfactor = "m"; *)
 R0_33 (net20[32], D, GSB);
rdp_io #(.l(5.1e-07), .w(4e-05), .m(1), .par1(1), .xf_subext(0))
(* integer passed_mfactor = "m"; *)
 R0_34 (net20[33], D, GSB);
rdp_io #(.l(5.1e-07), .w(4e-05), .m(1), .par1(1), .xf_subext(0))
(* integer passed_mfactor = "m"; *)
 R0_35 (net20[34], D, GSB);
rdp_io #(.l(5.1e-07), .w(4e-05), .m(1), .par1(1), .xf_subext(0))
(* integer passed_mfactor = "m"; *)
 R0_36 (net20[35], D, GSB);
rdp_io #(.l(5.1e-07), .w(4e-05), .m(1), .par1(1), .xf_subext(0))
(* integer passed_mfactor = "m"; *)
 R0_37 (net20[36], D, GSB);
rdp_io #(.l(5.1e-07), .w(4e-05), .m(1), .par1(1), .xf_subext(0))
(* integer passed_mfactor = "m"; *)
 R0_38 (net20[37], D, GSB);
rdp_io #(.l(5.1e-07), .w(4e-05), .m(1), .par1(1), .xf_subext(0))
(* integer passed_mfactor = "m"; *)
 R0_39 (net20[38], D, GSB);
rdp_io #(.l(5.1e-07), .w(4e-05), .m(1), .par1(1), .xf_subext(0))
(* integer passed_mfactor = "m"; *)
 R0_40 (net20[39], D, GSB);
rdp_io #(.l(5.1e-07), .w(4e-05), .m(1), .par1(1), .xf_subext(0))
(* integer passed_mfactor = "m"; *)
 R0_41 (net20[40], D, GSB);
rdp_io #(.l(5.1e-07), .w(4e-05), .m(1), .par1(1), .xf_subext(0))
(* integer passed_mfactor = "m"; *)
 R0_42 (net20[41], D, GSB);
rdp_io #(.l(5.1e-07), .w(4e-05), .m(1), .par1(1), .xf_subext(0))
(* integer passed_mfactor = "m"; *)
 R0_43 (net20[42], D, GSB);
rdp_io #(.l(5.1e-07), .w(4e-05), .m(1), .par1(1), .xf_subext(0))
(* integer passed_mfactor = "m"; *)
 R0_44 (net20[43], D, GSB);
rdp_io #(.l(5.1e-07), .w(4e-05), .m(1), .par1(1), .xf_subext(0))
(* integer passed_mfactor = "m"; *)
 R0_45 (net20[44], D, GSB);
rdp_io #(.l(5.1e-07), .w(4e-05), .m(1), .par1(1), .xf_subext(0))
(* integer passed_mfactor = "m"; *)
 R0_46 (net20[45], D, GSB);
rdp_io #(.l(5.1e-07), .w(4e-05), .m(1), .par1(1), .xf_subext(0))
(* integer passed_mfactor = "m"; *)
 R0_47 (net20[46], D, GSB);
rdp_io #(.l(5.1e-07), .w(4e-05), .m(1), .par1(1), .xf_subext(0))
(* integer passed_mfactor = "m"; *)
 R0_48 (net20[47], D, GSB);
rdp_io #(.l(5.1e-07), .w(4e-05), .m(1), .par1(1), .xf_subext(0))
(* integer passed_mfactor = "m"; *)
 R0_49 (net20[48], D, GSB);
rdp_io #(.l(5.1e-07), .w(4e-05), .m(1), .par1(1), .xf_subext(0))
(* integer passed_mfactor = "m"; *)
 R0_50 (net20[49], D, GSB);
dphnw #(.area(1.32132e-11), .perimeter(6.6e-07), .dbv(0), .m(1), .par1(1))
(* integer passed_mfactor = "m"; *)
 D0_1 (D, GSB);
dphnw #(.area(1.32132e-11), .perimeter(6.6e-07), .dbv(0), .m(1), .par1(1))
(* integer passed_mfactor = "m"; *)
 D0_2 (D, GSB);
dphnw #(.area(1.32132e-11), .perimeter(6.6e-07), .dbv(0), .m(1), .par1(1))
(* integer passed_mfactor = "m"; *)
 D0_3 (D, GSB);
dphnw #(.area(1.32132e-11), .perimeter(6.6e-07), .dbv(0), .m(1), .par1(1))
(* integer passed_mfactor = "m"; *)
 D0_4 (D, GSB);
dphnw #(.area(1.32132e-11), .perimeter(6.6e-07), .dbv(0), .m(1), .par1(1))
(* integer passed_mfactor = "m"; *)
 D0_5 (D, GSB);
dphnw #(.area(1.32132e-11), .perimeter(6.6e-07), .dbv(0), .m(1), .par1(1))
(* integer passed_mfactor = "m"; *)
 D0_6 (D, GSB);
dphnw #(.area(1.32132e-11), .perimeter(6.6e-07), .dbv(0), .m(1), .par1(1))
(* integer passed_mfactor = "m"; *)
 D0_7 (D, GSB);
dphnw #(.area(1.32132e-11), .perimeter(6.6e-07), .dbv(0), .m(1), .par1(1))
(* integer passed_mfactor = "m"; *)
 D0_8 (D, GSB);
dphnw #(.area(1.32132e-11), .perimeter(6.6e-07), .dbv(0), .m(1), .par1(1))
(* integer passed_mfactor = "m"; *)
 D0_9 (D, GSB);
dphnw #(.area(1.32132e-11), .perimeter(6.6e-07), .dbv(0), .m(1), .par1(1))
(* integer passed_mfactor = "m"; *)
 D0_10 (D, GSB);
dphnw #(.area(1.32132e-11), .perimeter(6.6e-07), .dbv(0), .m(1), .par1(1))
(* integer passed_mfactor = "m"; *)
 D0_11 (D, GSB);
dphnw #(.area(1.32132e-11), .perimeter(6.6e-07), .dbv(0), .m(1), .par1(1))
(* integer passed_mfactor = "m"; *)
 D0_12 (D, GSB);
dphnw #(.area(1.32132e-11), .perimeter(6.6e-07), .dbv(0), .m(1), .par1(1))
(* integer passed_mfactor = "m"; *)
 D0_13 (D, GSB);
dphnw #(.area(1.32132e-11), .perimeter(6.6e-07), .dbv(0), .m(1), .par1(1))
(* integer passed_mfactor = "m"; *)
 D0_14 (D, GSB);
dphnw #(.area(1.32132e-11), .perimeter(6.6e-07), .dbv(0), .m(1), .par1(1))
(* integer passed_mfactor = "m"; *)
 D0_15 (D, GSB);
dphnw #(.area(1.32132e-11), .perimeter(6.6e-07), .dbv(0), .m(1), .par1(1))
(* integer passed_mfactor = "m"; *)
 D0_16 (D, GSB);
dphnw #(.area(1.32132e-11), .perimeter(6.6e-07), .dbv(0), .m(1), .par1(1))
(* integer passed_mfactor = "m"; *)
 D0_17 (D, GSB);
dphnw #(.area(1.32132e-11), .perimeter(6.6e-07), .dbv(0), .m(1), .par1(1))
(* integer passed_mfactor = "m"; *)
 D0_18 (D, GSB);
dphnw #(.area(1.32132e-11), .perimeter(6.6e-07), .dbv(0), .m(1), .par1(1))
(* integer passed_mfactor = "m"; *)
 D0_19 (D, GSB);
dphnw #(.area(1.32132e-11), .perimeter(6.6e-07), .dbv(0), .m(1), .par1(1))
(* integer passed_mfactor = "m"; *)
 D0_20 (D, GSB);
dphnw #(.area(1.32132e-11), .perimeter(6.6e-07), .dbv(0), .m(1), .par1(1))
(* integer passed_mfactor = "m"; *)
 D0_21 (D, GSB);
dphnw #(.area(1.32132e-11), .perimeter(6.6e-07), .dbv(0), .m(1), .par1(1))
(* integer passed_mfactor = "m"; *)
 D0_22 (D, GSB);
dphnw #(.area(1.32132e-11), .perimeter(6.6e-07), .dbv(0), .m(1), .par1(1))
(* integer passed_mfactor = "m"; *)
 D0_23 (D, GSB);
dphnw #(.area(1.32132e-11), .perimeter(6.6e-07), .dbv(0), .m(1), .par1(1))
(* integer passed_mfactor = "m"; *)
 D0_24 (D, GSB);
dphnw #(.area(1.32132e-11), .perimeter(6.6e-07), .dbv(0), .m(1), .par1(1))
(* integer passed_mfactor = "m"; *)
 D0_25 (D, GSB);
dphnw #(.area(1.32132e-11), .perimeter(6.6e-07), .dbv(0), .m(1), .par1(1))
(* integer passed_mfactor = "m"; *)
 D0_26 (D, GSB);
dphnw #(.area(1.32132e-11), .perimeter(6.6e-07), .dbv(0), .m(1), .par1(1))
(* integer passed_mfactor = "m"; *)
 D0_27 (D, GSB);
dphnw #(.area(1.32132e-11), .perimeter(6.6e-07), .dbv(0), .m(1), .par1(1))
(* integer passed_mfactor = "m"; *)
 D0_28 (D, GSB);
dphnw #(.area(1.32132e-11), .perimeter(6.6e-07), .dbv(0), .m(1), .par1(1))
(* integer passed_mfactor = "m"; *)
 D0_29 (D, GSB);
dphnw #(.area(1.32132e-11), .perimeter(6.6e-07), .dbv(0), .m(1), .par1(1))
(* integer passed_mfactor = "m"; *)
 D0_30 (D, GSB);
dphnw #(.area(1.32132e-11), .perimeter(6.6e-07), .dbv(0), .m(1), .par1(1))
(* integer passed_mfactor = "m"; *)
 D0_31 (D, GSB);
dphnw #(.area(1.32132e-11), .perimeter(6.6e-07), .dbv(0), .m(1), .par1(1))
(* integer passed_mfactor = "m"; *)
 D0_32 (D, GSB);
dphnw #(.area(1.32132e-11), .perimeter(6.6e-07), .dbv(0), .m(1), .par1(1))
(* integer passed_mfactor = "m"; *)
 D0_33 (D, GSB);
dphnw #(.area(1.32132e-11), .perimeter(6.6e-07), .dbv(0), .m(1), .par1(1))
(* integer passed_mfactor = "m"; *)
 D0_34 (D, GSB);
dphnw #(.area(1.32132e-11), .perimeter(6.6e-07), .dbv(0), .m(1), .par1(1))
(* integer passed_mfactor = "m"; *)
 D0_35 (D, GSB);
dphnw #(.area(1.32132e-11), .perimeter(6.6e-07), .dbv(0), .m(1), .par1(1))
(* integer passed_mfactor = "m"; *)
 D0_36 (D, GSB);
dphnw #(.area(1.32132e-11), .perimeter(6.6e-07), .dbv(0), .m(1), .par1(1))
(* integer passed_mfactor = "m"; *)
 D0_37 (D, GSB);
dphnw #(.area(1.32132e-11), .perimeter(6.6e-07), .dbv(0), .m(1), .par1(1))
(* integer passed_mfactor = "m"; *)
 D0_38 (D, GSB);
dphnw #(.area(1.32132e-11), .perimeter(6.6e-07), .dbv(0), .m(1), .par1(1))
(* integer passed_mfactor = "m"; *)
 D0_39 (D, GSB);
dphnw #(.area(1.32132e-11), .perimeter(6.6e-07), .dbv(0), .m(1), .par1(1))
(* integer passed_mfactor = "m"; *)
 D0_40 (D, GSB);
dphnw #(.area(1.32132e-11), .perimeter(6.6e-07), .dbv(0), .m(1), .par1(1))
(* integer passed_mfactor = "m"; *)
 D0_41 (D, GSB);
dphnw #(.area(1.32132e-11), .perimeter(6.6e-07), .dbv(0), .m(1), .par1(1))
(* integer passed_mfactor = "m"; *)
 D0_42 (D, GSB);
dphnw #(.area(1.32132e-11), .perimeter(6.6e-07), .dbv(0), .m(1), .par1(1))
(* integer passed_mfactor = "m"; *)
 D0_43 (D, GSB);
dphnw #(.area(1.32132e-11), .perimeter(6.6e-07), .dbv(0), .m(1), .par1(1))
(* integer passed_mfactor = "m"; *)
 D0_44 (D, GSB);
dphnw #(.area(1.32132e-11), .perimeter(6.6e-07), .dbv(0), .m(1), .par1(1))
(* integer passed_mfactor = "m"; *)
 D0_45 (D, GSB);
dphnw #(.area(1.32132e-11), .perimeter(6.6e-07), .dbv(0), .m(1), .par1(1))
(* integer passed_mfactor = "m"; *)
 D0_46 (D, GSB);
dphnw #(.area(1.32132e-11), .perimeter(6.6e-07), .dbv(0), .m(1), .par1(1))
(* integer passed_mfactor = "m"; *)
 D0_47 (D, GSB);
dphnw #(.area(1.32132e-11), .perimeter(6.6e-07), .dbv(0), .m(1), .par1(1))
(* integer passed_mfactor = "m"; *)
 D0_48 (D, GSB);
dphnw #(.area(1.32132e-11), .perimeter(6.6e-07), .dbv(0), .m(1), .par1(1))
(* integer passed_mfactor = "m"; *)
 D0_49 (D, GSB);
dphnw #(.area(1.32132e-11), .perimeter(6.6e-07), .dbv(0), .m(1), .par1(1))
(* integer passed_mfactor = "m"; *)
 D0_50 (D, GSB);
ddnw #(.area(5.93593e-09), .perimeter(0.0003342), .dbv(0), .m(1), .par1(1), .xf_subext(0))
(* integer passed_mfactor = "m"; *)
 D1 (Sub, GSB);

endmodule
// Library - HV_CELLS, Cell - ioh_pe3isab_40_04, View - schematic
// LAST TIME SAVED: Feb 25 05:55:55 2015
// NETLIST TIME: Feb  9 05:08:09 2024

`worklib HV_CELLS
`view schematic

`timescale 1ns / 1ps
(* cds_ams_schematic *)

module ioh_pe3isab_40_04 (B, D, G, S);
inout  B, D, G, S;
pe3i #(.w(4e-05), .l(4e-07), .as(1.92e-11), .ad(1.92e-11), .ps(8.096e-05), .pd(8.096e-05), .nrs(0.00675), .nrd(0.00675), .m((1)*(1)), .par1((1)*(1)))
(* integer passed_mfactor = "m"; *)
 MPX (net17, G, S, B);
rdp3 #(.l(4.3e-07), .w(4e-05), .m(1), .par1(1))
(* integer passed_mfactor = "m"; *)
 R0 (net17, D, B);

endmodule
// Library - HV_CELLS, Cell - ioh_pe3isabhv_2800gcr, View - schematic
// LAST TIME SAVED: Feb 25 05:55:56 2015
// NETLIST TIME: Feb  9 05:08:09 2024

`worklib HV_CELLS
`view schematic

`timescale 1ns / 1ps
(* cds_ams_schematic *)

module ioh_pe3isabhv_2800gcr (D, SB, Sub);
inout  D, SB, Sub;
wire net20;
ioh_pe3isab_40_04 MP_1 (.D( D ), .B( SB ), .G( net20 ), .S( SB ));
ioh_pe3isab_40_04 MP_2 (.D( D ), .B( SB ), .G( net20 ), .S( SB ));
ioh_pe3isab_40_04 MP_3 (.D( D ), .B( SB ), .G( net20 ), .S( SB ));
ioh_pe3isab_40_04 MP_4 (.D( D ), .B( SB ), .G( net20 ), .S( SB ));
ioh_pe3isab_40_04 MP_5 (.D( D ), .B( SB ), .G( net20 ), .S( SB ));
ioh_pe3isab_40_04 MP_6 (.D( D ), .B( SB ), .G( net20 ), .S( SB ));
ioh_pe3isab_40_04 MP_7 (.D( D ), .B( SB ), .G( net20 ), .S( SB ));
ioh_pe3isab_40_04 MP_8 (.D( D ), .B( SB ), .G( net20 ), .S( SB ));
ioh_pe3isab_40_04 MP_9 (.D( D ), .B( SB ), .G( net20 ), .S( SB ));
ioh_pe3isab_40_04 MP_10 (.D( D ), .B( SB ), .G( net20 ), .S( SB ));
ioh_pe3isab_40_04 MP_11 (.D( D ), .B( SB ), .G( net20 ), .S( SB ));
ioh_pe3isab_40_04 MP_12 (.D( D ), .B( SB ), .G( net20 ), .S( SB ));
ioh_pe3isab_40_04 MP_13 (.D( D ), .B( SB ), .G( net20 ), .S( SB ));
ioh_pe3isab_40_04 MP_14 (.D( D ), .B( SB ), .G( net20 ), .S( SB ));
ioh_pe3isab_40_04 MP_15 (.D( D ), .B( SB ), .G( net20 ), .S( SB ));
ioh_pe3isab_40_04 MP_16 (.D( D ), .B( SB ), .G( net20 ), .S( SB ));
ioh_pe3isab_40_04 MP_17 (.D( D ), .B( SB ), .G( net20 ), .S( SB ));
ioh_pe3isab_40_04 MP_18 (.D( D ), .B( SB ), .G( net20 ), .S( SB ));
ioh_pe3isab_40_04 MP_19 (.D( D ), .B( SB ), .G( net20 ), .S( SB ));
ioh_pe3isab_40_04 MP_20 (.D( D ), .B( SB ), .G( net20 ), .S( SB ));
ioh_pe3isab_40_04 MP_21 (.D( D ), .B( SB ), .G( net20 ), .S( SB ));
ioh_pe3isab_40_04 MP_22 (.D( D ), .B( SB ), .G( net20 ), .S( SB ));
ioh_pe3isab_40_04 MP_23 (.D( D ), .B( SB ), .G( net20 ), .S( SB ));
ioh_pe3isab_40_04 MP_24 (.D( D ), .B( SB ), .G( net20 ), .S( SB ));
ioh_pe3isab_40_04 MP_25 (.D( D ), .B( SB ), .G( net20 ), .S( SB ));
ioh_pe3isab_40_04 MP_26 (.D( D ), .B( SB ), .G( net20 ), .S( SB ));
ioh_pe3isab_40_04 MP_27 (.D( D ), .B( SB ), .G( net20 ), .S( SB ));
ioh_pe3isab_40_04 MP_28 (.D( D ), .B( SB ), .G( net20 ), .S( SB ));
ioh_pe3isab_40_04 MP_29 (.D( D ), .B( SB ), .G( net20 ), .S( SB ));
ioh_pe3isab_40_04 MP_30 (.D( D ), .B( SB ), .G( net20 ), .S( SB ));
ioh_pe3isab_40_04 MP_31 (.D( D ), .B( SB ), .G( net20 ), .S( SB ));
ioh_pe3isab_40_04 MP_32 (.D( D ), .B( SB ), .G( net20 ), .S( SB ));
ioh_pe3isab_40_04 MP_33 (.D( D ), .B( SB ), .G( net20 ), .S( SB ));
ioh_pe3isab_40_04 MP_34 (.D( D ), .B( SB ), .G( net20 ), .S( SB ));
ioh_pe3isab_40_04 MP_35 (.D( D ), .B( SB ), .G( net20 ), .S( SB ));
ioh_pe3isab_40_04 MP_36 (.D( D ), .B( SB ), .G( net20 ), .S( SB ));
ioh_pe3isab_40_04 MP_37 (.D( D ), .B( SB ), .G( net20 ), .S( SB ));
ioh_pe3isab_40_04 MP_38 (.D( D ), .B( SB ), .G( net20 ), .S( SB ));
ioh_pe3isab_40_04 MP_39 (.D( D ), .B( SB ), .G( net20 ), .S( SB ));
ioh_pe3isab_40_04 MP_40 (.D( D ), .B( SB ), .G( net20 ), .S( SB ));
ioh_pe3isab_40_04 MP_41 (.D( D ), .B( SB ), .G( net20 ), .S( SB ));
ioh_pe3isab_40_04 MP_42 (.D( D ), .B( SB ), .G( net20 ), .S( SB ));
ioh_pe3isab_40_04 MP_43 (.D( D ), .B( SB ), .G( net20 ), .S( SB ));
ioh_pe3isab_40_04 MP_44 (.D( D ), .B( SB ), .G( net20 ), .S( SB ));
ioh_pe3isab_40_04 MP_45 (.D( D ), .B( SB ), .G( net20 ), .S( SB ));
ioh_pe3isab_40_04 MP_46 (.D( D ), .B( SB ), .G( net20 ), .S( SB ));
ioh_pe3isab_40_04 MP_47 (.D( D ), .B( SB ), .G( net20 ), .S( SB ));
ioh_pe3isab_40_04 MP_48 (.D( D ), .B( SB ), .G( net20 ), .S( SB ));
ioh_pe3isab_40_04 MP_49 (.D( D ), .B( SB ), .G( net20 ), .S( SB ));
ioh_pe3isab_40_04 MP_50 (.D( D ), .B( SB ), .G( net20 ), .S( SB ));
ioh_pe3isab_40_04 MP_51 (.D( D ), .B( SB ), .G( net20 ), .S( SB ));
ioh_pe3isab_40_04 MP_52 (.D( D ), .B( SB ), .G( net20 ), .S( SB ));
ioh_pe3isab_40_04 MP_53 (.D( D ), .B( SB ), .G( net20 ), .S( SB ));
ioh_pe3isab_40_04 MP_54 (.D( D ), .B( SB ), .G( net20 ), .S( SB ));
ioh_pe3isab_40_04 MP_55 (.D( D ), .B( SB ), .G( net20 ), .S( SB ));
ioh_pe3isab_40_04 MP_56 (.D( D ), .B( SB ), .G( net20 ), .S( SB ));
ioh_pe3isab_40_04 MP_57 (.D( D ), .B( SB ), .G( net20 ), .S( SB ));
ioh_pe3isab_40_04 MP_58 (.D( D ), .B( SB ), .G( net20 ), .S( SB ));
ioh_pe3isab_40_04 MP_59 (.D( D ), .B( SB ), .G( net20 ), .S( SB ));
ioh_pe3isab_40_04 MP_60 (.D( D ), .B( SB ), .G( net20 ), .S( SB ));
ioh_pe3isab_40_04 MP_61 (.D( D ), .B( SB ), .G( net20 ), .S( SB ));
ioh_pe3isab_40_04 MP_62 (.D( D ), .B( SB ), .G( net20 ), .S( SB ));
ioh_pe3isab_40_04 MP_63 (.D( D ), .B( SB ), .G( net20 ), .S( SB ));
ioh_pe3isab_40_04 MP_64 (.D( D ), .B( SB ), .G( net20 ), .S( SB ));
ioh_pe3isab_40_04 MP_65 (.D( D ), .B( SB ), .G( net20 ), .S( SB ));
ioh_pe3isab_40_04 MP_66 (.D( D ), .B( SB ), .G( net20 ), .S( SB ));
ioh_pe3isab_40_04 MP_67 (.D( D ), .B( SB ), .G( net20 ), .S( SB ));
ioh_pe3isab_40_04 MP_68 (.D( D ), .B( SB ), .G( net20 ), .S( SB ));
ioh_pe3isab_40_04 MP_69 (.D( D ), .B( SB ), .G( net20 ), .S( SB ));
ioh_pe3isab_40_04 MP_70 (.D( D ), .B( SB ), .G( net20 ), .S( SB ));
dp3 #(.area(2.64196e-11), .perimeter(1.32e-06), .dbv(0), .m(1), .par1(1))
(* integer passed_mfactor = "m"; *)
 MD_1 (D, SB);
dp3 #(.area(2.64196e-11), .perimeter(1.32e-06), .dbv(0), .m(1), .par1(1))
(* integer passed_mfactor = "m"; *)
 MD_2 (D, SB);
dp3 #(.area(2.64196e-11), .perimeter(1.32e-06), .dbv(0), .m(1), .par1(1))
(* integer passed_mfactor = "m"; *)
 MD_3 (D, SB);
dp3 #(.area(2.64196e-11), .perimeter(1.32e-06), .dbv(0), .m(1), .par1(1))
(* integer passed_mfactor = "m"; *)
 MD_4 (D, SB);
dp3 #(.area(2.64196e-11), .perimeter(1.32e-06), .dbv(0), .m(1), .par1(1))
(* integer passed_mfactor = "m"; *)
 MD_5 (D, SB);
dp3 #(.area(2.64196e-11), .perimeter(1.32e-06), .dbv(0), .m(1), .par1(1))
(* integer passed_mfactor = "m"; *)
 MD_6 (D, SB);
dp3 #(.area(2.64196e-11), .perimeter(1.32e-06), .dbv(0), .m(1), .par1(1))
(* integer passed_mfactor = "m"; *)
 MD_7 (D, SB);
dp3 #(.area(2.64196e-11), .perimeter(1.32e-06), .dbv(0), .m(1), .par1(1))
(* integer passed_mfactor = "m"; *)
 MD_8 (D, SB);
dp3 #(.area(2.64196e-11), .perimeter(1.32e-06), .dbv(0), .m(1), .par1(1))
(* integer passed_mfactor = "m"; *)
 MD_9 (D, SB);
dp3 #(.area(2.64196e-11), .perimeter(1.32e-06), .dbv(0), .m(1), .par1(1))
(* integer passed_mfactor = "m"; *)
 MD_10 (D, SB);
dp3 #(.area(2.64196e-11), .perimeter(1.32e-06), .dbv(0), .m(1), .par1(1))
(* integer passed_mfactor = "m"; *)
 MD_11 (D, SB);
dp3 #(.area(2.64196e-11), .perimeter(1.32e-06), .dbv(0), .m(1), .par1(1))
(* integer passed_mfactor = "m"; *)
 MD_12 (D, SB);
dp3 #(.area(2.64196e-11), .perimeter(1.32e-06), .dbv(0), .m(1), .par1(1))
(* integer passed_mfactor = "m"; *)
 MD_13 (D, SB);
dp3 #(.area(2.64196e-11), .perimeter(1.32e-06), .dbv(0), .m(1), .par1(1))
(* integer passed_mfactor = "m"; *)
 MD_14 (D, SB);
dp3 #(.area(2.64196e-11), .perimeter(1.32e-06), .dbv(0), .m(1), .par1(1))
(* integer passed_mfactor = "m"; *)
 MD_15 (D, SB);
dp3 #(.area(2.64196e-11), .perimeter(1.32e-06), .dbv(0), .m(1), .par1(1))
(* integer passed_mfactor = "m"; *)
 MD_16 (D, SB);
dp3 #(.area(2.64196e-11), .perimeter(1.32e-06), .dbv(0), .m(1), .par1(1))
(* integer passed_mfactor = "m"; *)
 MD_17 (D, SB);
dp3 #(.area(2.64196e-11), .perimeter(1.32e-06), .dbv(0), .m(1), .par1(1))
(* integer passed_mfactor = "m"; *)
 MD_18 (D, SB);
dp3 #(.area(2.64196e-11), .perimeter(1.32e-06), .dbv(0), .m(1), .par1(1))
(* integer passed_mfactor = "m"; *)
 MD_19 (D, SB);
dp3 #(.area(2.64196e-11), .perimeter(1.32e-06), .dbv(0), .m(1), .par1(1))
(* integer passed_mfactor = "m"; *)
 MD_20 (D, SB);
dp3 #(.area(2.64196e-11), .perimeter(1.32e-06), .dbv(0), .m(1), .par1(1))
(* integer passed_mfactor = "m"; *)
 MD_21 (D, SB);
dp3 #(.area(2.64196e-11), .perimeter(1.32e-06), .dbv(0), .m(1), .par1(1))
(* integer passed_mfactor = "m"; *)
 MD_22 (D, SB);
dp3 #(.area(2.64196e-11), .perimeter(1.32e-06), .dbv(0), .m(1), .par1(1))
(* integer passed_mfactor = "m"; *)
 MD_23 (D, SB);
dp3 #(.area(2.64196e-11), .perimeter(1.32e-06), .dbv(0), .m(1), .par1(1))
(* integer passed_mfactor = "m"; *)
 MD_24 (D, SB);
dp3 #(.area(2.64196e-11), .perimeter(1.32e-06), .dbv(0), .m(1), .par1(1))
(* integer passed_mfactor = "m"; *)
 MD_25 (D, SB);
dp3 #(.area(2.64196e-11), .perimeter(1.32e-06), .dbv(0), .m(1), .par1(1))
(* integer passed_mfactor = "m"; *)
 MD_26 (D, SB);
dp3 #(.area(2.64196e-11), .perimeter(1.32e-06), .dbv(0), .m(1), .par1(1))
(* integer passed_mfactor = "m"; *)
 MD_27 (D, SB);
dp3 #(.area(2.64196e-11), .perimeter(1.32e-06), .dbv(0), .m(1), .par1(1))
(* integer passed_mfactor = "m"; *)
 MD_28 (D, SB);
dp3 #(.area(2.64196e-11), .perimeter(1.32e-06), .dbv(0), .m(1), .par1(1))
(* integer passed_mfactor = "m"; *)
 MD_29 (D, SB);
dp3 #(.area(2.64196e-11), .perimeter(1.32e-06), .dbv(0), .m(1), .par1(1))
(* integer passed_mfactor = "m"; *)
 MD_30 (D, SB);
dp3 #(.area(2.64196e-11), .perimeter(1.32e-06), .dbv(0), .m(1), .par1(1))
(* integer passed_mfactor = "m"; *)
 MD_31 (D, SB);
dp3 #(.area(2.64196e-11), .perimeter(1.32e-06), .dbv(0), .m(1), .par1(1))
(* integer passed_mfactor = "m"; *)
 MD_32 (D, SB);
dp3 #(.area(2.64196e-11), .perimeter(1.32e-06), .dbv(0), .m(1), .par1(1))
(* integer passed_mfactor = "m"; *)
 MD_33 (D, SB);
dp3 #(.area(2.64196e-11), .perimeter(1.32e-06), .dbv(0), .m(1), .par1(1))
(* integer passed_mfactor = "m"; *)
 MD_34 (D, SB);
dp3 #(.area(2.64196e-11), .perimeter(1.32e-06), .dbv(0), .m(1), .par1(1))
(* integer passed_mfactor = "m"; *)
 MD_35 (D, SB);
ddnw #(.area(5.99695e-09), .perimeter(0.0003352), .dbv(0), .m(1), .par1(1), .xf_subext(0))
(* integer passed_mfactor = "m"; *)
 D0 (Sub, SB);
rnp1 #(.l(2.55e-05), .w(4.2e-07), .m(1), .par1(1))
(* integer passed_mfactor = "m"; *)
 R0 (SB, net20);

endmodule
// Library - HV_CELLS, Cell - ioh_d5pk, View - schematic
// LAST TIME SAVED: Feb 25 05:55:49 2015
// NETLIST TIME: Feb  9 05:08:09 2024

`worklib HV_CELLS
`view schematic

`timescale 1ns / 1ps
(* cds_ams_schematic *)

module ioh_d5pk (A_l, K_h, Sub);
inout  A_l, K_h, Sub;
wire net29;
wire net26;
wire net18;
wire net23;
ioh_pmbsabhv_2000 I3 (.Sub( Sub ), .D( net26 ), .GSB( net29 ));
ioh_pmbsabhv_2000 I4 (.Sub( Sub ), .D( net18 ), .GSB( net26 ));
ioh_pmbsabhv_2000 I2 (.Sub( Sub ), .D( net29 ), .GSB( net23 ));
ioh_pmbsabhv_2000 I1 (.Sub( Sub ), .D( net23 ), .GSB( K_h ));
ioh_pe3isabhv_2800gcr I5 (.Sub( Sub ), .SB( net18 ), .D( A_l ));

endmodule
// Library - IORING, Cell - ioring, View - schematic
// LAST TIME SAVED: Feb  7 11:24:12 2024
// NETLIST TIME: Feb  9 05:08:09 2024

`worklib IORING
`view schematic

`timescale 1ns / 1ps
(* cds_ams_schematic *)

module ioring (CLK, ENABLE, GNDA, GNDD, GNDHV, GNDOHV, GNDOR, GNDORA, INL, OUT0, OUT1, OUT2, OUTHV, OUTL, PSUB, RESET, VDDA, VDDD, VDDHV, VDDOR, VDDORA, clk_core, enable_core, inl_core, out0_core, out1_core, out2_core, reset_core);
inout  CLK, ENABLE, GNDA, GNDD, GNDHV, GNDOHV, GNDOR, GNDORA, INL, OUT0, OUT1, OUT2, OUTHV, OUTL, PSUB, RESET, VDDA, VDDD, VDDHV, VDDOR, VDDORA, clk_core, enable_core, inl_core, out0_core, out1_core, out2_core, reset_core;
wire net4;
wire net3;
wire net1;
wire net10;
wire net11;
wire net14;
wire net15;
wire net12;
wire net16;
wire net9;
wire net8;
wire net2;
wire net6;
wire net5;
VDDORPADPC I18 (.PSUB( PSUB ), .GNDRI( GNDORA ), .VDD3I( VDDA ), .GNDI( GNDA ), .VDDORI( VDDORA ), .GNDOI( GNDORA ));
VDDORPADPC I1 (.PSUB( PSUB ), .GNDRI( GNDOR ), .VDD3I( VDDD ), .GNDI( GNDD ), .VDDORI( VDDOR ), .GNDOI( GNDOR ));
VDDPADPC I21 (.PSUB( PSUB ), .VDD3I( VDDA ), .GNDI( GNDA ), .VDDRI( VDDOR ), .GNDOI( GNDORA ), .VDDOI( VDDOR ), .GNDRI( GNDORA ));
VDDPADPC I3 (.PSUB( PSUB ), .VDD3I( VDDD ), .GNDI( GNDD ), .VDDRI( VDDOR ), .GNDOI( GNDOR ), .VDDOI( VDDOR ), .GNDRI( GNDOR ));
GNDORPADPC I20 (.VDDOI( VDDORA ), .GNDI( GNDA ), .VDD3I( VDDA ), .GNDORI( GNDORA ), .VDDRI( VDDORA ), .PSUB( PSUB ));
GNDORPADPC I0 (.VDDOI( VDDOR ), .GNDI( GNDD ), .VDD3I( VDDD ), .GNDORI( GNDOR ), .VDDRI( VDDOR ), .PSUB( PSUB ));
PSUBPADPC I4 (.VDDOI( VDDOR ), .PSUB( PSUB ), .VDD3I( VDDD ), .GNDI( GNDD ), .VDDRI( VDDOR ), .GNDOI( GNDOR ), .GNDRI( GNDOR ));
GNDPADPC I19 (.PSUB( PSUB ), .VDD3I( VDDA ), .GNDI( GNDA ), .VDDRI( VDDORA ), .GNDOI( GNDORA ), .VDDOI( VDDORA ), .GNDRI( GNDORA ));
GNDPADPC I5 (.PSUB( PSUB ), .VDD3I( VDDD ), .GNDI( GNDD ), .VDDRI( VDDOR ), .GNDOI( GNDOR ), .VDDOI( VDDOR ), .GNDRI( GNDOR ));
ICPC I11 (.VDD3I( VDDD ), .GNDI( GNDD ), .GNDRI( GNDOR ), .VDDRI( VDDOR ), .VDDOI( VDDOR ), .PSUB( PSUB ), .GNDOI( GNDOR ), .Y( reset_core ), .PAD( RESET ), .PI( GNDD ), .PO( net4 ));
ICPC I10 (.VDD3I( VDDD ), .GNDI( GNDD ), .GNDRI( GNDOR ), .VDDRI( VDDOR ), .VDDOI( VDDOR ), .PSUB( PSUB ), .GNDOI( GNDOR ), .Y( clk_core ), .PAD( CLK ), .PI( GNDD ), .PO( net3 ));
ICPC I9 (.VDD3I( VDDD ), .GNDI( GNDD ), .GNDRI( GNDOR ), .VDDRI( VDDOR ), .VDDOI( VDDOR ), .PSUB( PSUB ), .GNDOI( GNDOR ), .Y( enable_core ), .PAD( ENABLE ), .PI( GNDD ), .PO( net1 ));
PWRCUTDCPC I35 (.VDD3I1( net16 ), .GNDRI2( GNDOR ), .VDDOI2( VDDOR ), .GNDOI2( GNDOR ), .GNDI2( GNDD ), .VDDRI2( VDDOR ), .VDDOI1( net12 ), .GNDOI1( GNDOHV ), .VDDRI1( net15 ), .PSUB( net14 ), .VDD3I2( VDDD ), .GNDRI1( net11 ), .GNDI1( net10 ));
PWRCUTDCPC I34 (.VDD3I1( VDDA ), .GNDRI2( net5 ), .VDDOI2( net6 ), .GNDOI2( GNDOHV ), .GNDI2( net2 ), .VDDRI2( net8 ), .VDDOI1( VDDORA ), .GNDOI1( GNDORA ), .VDDRI1( VDDORA ), .PSUB( PSUB ), .VDD3I2( net9 ), .GNDRI1( GNDORA ), .GNDI1( GNDA ));
PWRCUTDCPC I12 (.VDD3I1( VDDD ), .GNDRI2( GNDORA ), .VDDOI2( VDDORA ), .GNDOI2( GNDORA ), .GNDI2( GNDA ), .VDDRI2( VDDORA ), .VDDOI1( VDDOR ), .GNDOI1( GNDOR ), .VDDRI1( VDDOR ), .PSUB( PSUB ), .VDD3I2( VDDA ), .GNDRI1( GNDOR ), .GNDI1( GNDD ));
BT4PC I17 (.PAD( OUT2 ), .A( out2_core ), .EN( GNDD ), .GNDRI( GNDOR ), .PSUB( PSUB ), .VDD3I( VDDD ), .GNDI( GNDD ), .GNDOI( GNDOR ), .VDDOI( VDDOR ), .VDDRI( VDDOR ));
BT4PC I16 (.PAD( OUT1 ), .A( out1_core ), .EN( GNDD ), .GNDRI( GNDOR ), .PSUB( PSUB ), .VDD3I( VDDD ), .GNDI( GNDD ), .GNDOI( GNDOR ), .VDDOI( VDDOR ), .VDDRI( VDDOR ));
BT4PC I15 (.PAD( OUT0 ), .A( out0_core ), .EN( GNDD ), .GNDRI( GNDOR ), .PSUB( PSUB ), .VDD3I( VDDD ), .GNDI( GNDD ), .GNDOI( GNDOR ), .VDDOI( VDDOR ), .VDDRI( VDDOR ));
APR04DPC I22 (.VDDRI( VDDORA ), .VDD3I( VDDA ), .VDDOI( VDDORA ), .PSUB( PSUB ), .GNDRI( GNDORA ), .GNDI( GNDA ), .GNDOI( GNDORA ), .Y( inl_core ), .PAD( INL ));
APR00DPC I23 (.VDD3I( VDDA ), .VDDOI( VDDORA ), .GNDRI( GNDORA ), .GNDI( GNDA ), .PSUB( PSUB ), .VDDRI( VDDORA ), .GNDOI( GNDORA ), .PAD( OUTL ));
HVDD4DJ5PKFs I24 (.PAD( VDDHV ), .GNDO( GNDOHV ), .IGND( GNDHV ));
HVDD4D2PK I36 (.PAD( GNDHV ), .GND( GNDOHV ));
HVD4SJD1R5PKFs I33 (.IGND( GNDHV ), .GNDO( GNDOHV ), .PAD( OUTHV ));

endmodule
// Library - INV_LP, Cell - inv, View - schematic
// LAST TIME SAVED: Feb  4 10:15:33 2024
// NETLIST TIME: Feb  9 05:08:09 2024

`worklib INV_LP
`view schematic

`timescale 1ns / 1ps
(* cds_ams_schematic *)

module inv (IN, OUT, VD, VS);
inout  IN, OUT, VD, VS;
ne3 #(.w(2e-06), .l(3.5e-07), .as(9.6e-13), .ad(9.6e-13), .ps(4.96e-06), .pd(4.96e-06), .nrs(0.135), .nrd(0.135), .m((1)*(1)), .par1((1)*(1)), .xf_subext(0))
(* integer passed_mfactor = "m"; *)
 M0 (OUT, IN, VS, VS);
pe3 #(.w(2e-06), .l(3e-07), .as(9.6e-13), .ad(9.6e-13), .ps(4.96e-06), .pd(4.96e-06), .nrs(0.135), .nrd(0.135), .m((1)*(1)), .par1((1)*(1)))
(* integer passed_mfactor = "m"; *)
 M1 (OUT, IN, VD, VD);

endmodule
// Library - INV_HV, Cell - inv_hv, View - schematic
// LAST TIME SAVED: Feb  5 02:38:24 2024
// NETLIST TIME: Feb  9 05:08:09 2024

`worklib INV_HV
`view schematic

`timescale 1ns / 1ps
(* cds_ams_schematic *)

module inv_hv (GNDHV, IN, OUT, VDDHV, VSUB);
inout  GNDHV, IN, OUT, VDDHV, VSUB;
nedia #(.w(4e-05), .l(1.25e-06), .m((1)*(1)), .par1((1)*(1)), .extlay(0), .xf_subext(0))
(* integer passed_mfactor = "m"; *)
 M0 (OUT, IN, GNDHV, VSUB);
rpp1k1_3 #(.l(0.000103425), .w(1e-05), .m(1), .par1(1))
(* integer passed_mfactor = "m"; *)
 R0 (VDDHV, OUT, VSUB);

endmodule
// Library - TOP, Cell - top, View - schematic
// LAST TIME SAVED: Feb  7 07:37:55 2024
// NETLIST TIME: Feb  9 05:08:09 2024

`worklib TOP
`view schematic

`timescale 1ns / 1ps
(* cds_ams_schematic *)

module top (CLK, ENABLE, GNDA, GNDD, GNDHV, GNDOHV, GNDOR, GNDORA, INL, OUT0, OUT1, OUT2, OUTHV, OUTL, PSUB, RESET, VDDA, VDDD, VDDHV, VDDOR, VDDORA);
inout  CLK, ENABLE, GNDA, GNDD, GNDHV, GNDOHV, GNDOR, GNDORA, INL, OUT0, OUT1, OUT2, OUTHV, OUTL, PSUB, RESET, VDDA, VDDD, VDDHV, VDDOR, VDDORA;
wire [7:0] out;
wire clk;
wire enable;
wire reset;
ioring I0 (.GNDA( GNDA ), .GNDD( GNDD ), .GNDHV( GNDHV ), .GNDOHV( GNDOHV ), .GNDOR( GNDOR ), .GNDORA( GNDORA ), .VDDA( VDDA ), .VDDD( VDDD ), .VDDHV( VDDHV ), .VDDOR( VDDOR ), .VDDORA( VDDORA ), .reset_core( reset ), .out2_core( out[2] ), .out1_core( out[1] ), .out0_core( out[0] ), .inl_core( INL ), .enable_core( enable ), .clk_core( clk ), .ENABLE( ENABLE ), .CLK( CLK ), .RESET( RESET ), .PSUB( PSUB ), .OUTL( OUTL ), .OUTHV( OUTHV ), .OUT2( OUT2 ), .OUT1( OUT1 ), .OUT0( OUT0 ), .INL( INL ));
inv I1 (.VS( GNDA ), .VD( VDDA ), .OUT( OUTL ), .IN( INL ));
inv_hv I2 (.GNDHV( GNDHV ), .VSUB( PSUB ), .VDDHV( VDDHV ), .OUT( OUTHV ), .IN( out[2] ));
counter (*  integer cds_net_set [0:1] = { "power_vdd3i","ground_gnd3i" }; integer power_vdd3i = "VDDD"; integer ground_gnd3i = "GNDD";  *)  I3 (.out( out[7:0] ), .reset( reset ), .clk( clk ), .enable( enable ));

endmodule
// Library - TOP, Cell - top_tb, View - schematic
// LAST TIME SAVED: Feb  9 05:01:40 2024
// NETLIST TIME: Feb  9 05:08:09 2024

`worklib TOP
`view schematic

`timescale 1ns / 1ps
(* cds_ams_schematic *)

module top_tb ( );
wire clk;
wire enable;
wire in_l;
wire reset;
wire out0;
wire out1;
wire out2;
wire out_h;
wire out_l;
wire VDDHV;
wire VDDD;
wire VDDA;
wire net7;
wire net12;
wire net8;
wire net15;
wire net17;
wire net9;
wire net13;
top I0 (.GNDA( net13 ), .GNDD( net9 ), .GNDHV( net17 ), .GNDOHV( net15 ), .GNDOR( net8 ), .GNDORA( net12 ), .PSUB( net7 ), .VDDA( VDDA ), .VDDD( VDDD ), .VDDHV( VDDHV ), .VDDOR( VDDD ), .VDDORA( VDDA ), .OUTL( out_l ), .OUTHV( out_h ), .OUT2( out2 ), .OUT1( out1 ), .OUT0( out0 ), .RESET( reset ), .INL( in_l ), .ENABLE( enable ), .CLK( clk ));
counter_stimulus I1 (.clk( clk ), .enable( enable ), .reset( reset ));
vsource #(.dc(0), .type("dc")) V9 (net16, cds_globals.\gnd! );
vsource #(.dc(0), .type("dc")) V8 (net14, cds_globals.\gnd! );
vsource #(.dc(0), .type("dc")) V7 (net11, cds_globals.\gnd! );
vsource #(.dc(0), .type("dc")) V6 (net10, cds_globals.\gnd! );
vsource #(.dc(0), .type("dc")) V5 (net6, cds_globals.\gnd! );
vsource #(.dc(0), .type("dc")) V4 (net5, cds_globals.\gnd! );
vsource #(.dc(0), .type("dc")) V3 (net4, cds_globals.\gnd! );
vsource #(.dc(40), .type("dc")) V2 (net3, cds_globals.\gnd! );
vsource #(.dc(3.3), .type("dc")) V1 (net2, cds_globals.\gnd! );
vsource #(.dc(3.3), .type("dc")) V0 (net1, cds_globals.\gnd! );
resistor #(.r(0.1)) R9 (net17, net16);
resistor #(.r(0.1)) R8 (net15, net14);
resistor #(.r(0.1)) R7 (net13, net11);
resistor #(.r(0.1)) R6 (net12, net10);
resistor #(.r(0.1)) R5 (net9, net6);
resistor #(.r(0.1)) R4 (net8, net5);
resistor #(.r(0.1)) R3 (net7, net4);
resistor #(.r(0.1)) R2 (VDDHV, net3);
resistor #(.r(0.1)) R1 (VDDA, net2);
resistor #(.r(0.1)) R0 (VDDD, net1);
vsource #(.type("pulse"), .val0(0), .val1(3.3), .period(1e-07), .delay(1e-08), .rise(1e-09), .fall(1e-09), .width(5e-08)) V10 (in_l, cds_globals.\gnd! );

endmodule
`noworklib
`noview
