// -----------------------------------------------------------------------------
// (c) Copyright 2010 Cadence Design Systems, Inc. All rights reserved worldwide.
// -----------------------------------------------------------------------------

// Binding AMSD Control Block for config TOP.top_tb:config_sch
// Created On: Feb 12 01:30:48 2024
// NOTE      : DO NOT change this system generated file.

amsd {
	config designtop="TOP.top_tb:schematic"

	config cell="ne3i" view="analogtext"
	config cell="ON211JI3VX1" lib="D_CELLS_JI3V" view="cmos_sch"
	config cell="dipdnwmv" view="analogtext"
	config cell="jio_pe3i_pc" lib="IO_CELLS_JIC3V" view="cmos_sch"
	config cell="GNDORPADPC" lib="IO_CELLS_JIC3V" view="cmos_sch"
	config cell="rpp1k1_3" view="analogtext"
	config cell="nand2ji3v" lib="GATES_JI3V" view="schematic"
	config cell="rdp_io" view="analogtext"
	config cell="CORNERESDPC" lib="IO_CELLS_JIC3V" view="cmos_sch"
	config cell="ioh_iscrd2_4x100" lib="HV_CELLS" view="schematic"
	config cell="NO2JI3VX0" lib="D_CELLS_JI3V" view="cmos_sch"
	config cell="jio_tp4_pc" lib="IO_CELLS_JIC3V" view="cmos_sch"
	config cell="BUJI3VX0" lib="D_CELLS_JI3V" view="cmos_sch"
	config cell="resistor" view="analogtext"
	config cell="pe3" view="analogtext"
	config cell="nedia" view="analogtext"
	config cell="DECAP10JI3V" lib="D_CELLS_JI3V" view="cmos_sch"
	config cell="ioh_pe3isab_40_04" lib="HV_CELLS" view="schematic"
	config cell="ddnw" view="analogtext"
	config cell="DLY1JI3VX1" lib="D_CELLS_JI3V" view="cmos_sch"
	config cell="jio_lviodio_pc" lib="IO_CELLS_JIC3V" view="cmos_sch"
	config cell="counter_stimulus" lib="COUNTER_JI3" view="verilogams"
	config cell="o2na3ji3v" lib="GATES_JI3V" view="schematic"
	config cell="top" lib="TOP" view="schematic"
	config cell="nor2ji3v" lib="GATES_JI3V" view="schematic"
	config cell="o2na2ji3v" lib="GATES_JI3V" view="schematic"
	config cell="BUJI3VX16" lib="D_CELLS_JI3V" view="cmos_sch"
	config cell="ioh_pmbsab_15_10" lib="HV_CELLS" view="schematic"
	config cell="rpp1" view="analogtext"
	config cell="INJI3VX0" lib="D_CELLS_JI3V" view="cmos_sch"
	config cell="AN22JI3VX1" lib="D_CELLS_JI3V" view="cmos_sch"
	config cell="jio_opdio_pc" lib="IO_CELLS_JIC3V" view="cmos_sch"
	config cell="NA2JI3VX0" lib="D_CELLS_JI3V" view="cmos_sch"
	config cell="rpp1s" view="analogtext"
	config cell="inv" lib="INV_LP" view="schematic"
	config cell="jio_bufc_pc" lib="IO_CELLS_JIC3V" view="cmos_sch"
	config cell="ioh_pe3isabhv_1050gcr" lib="HV_CELLS" view="schematic"
	config cell="DFRQJI3VX2" lib="D_CELLS_JI3V" view="cmos_sch"
	config cell="dpdnw" view="analogtext"
	config cell="dp3" view="analogtext"
	config cell="APR04DPC" lib="IO_CELLS_JIC3V" view="cmos_sch"
	config cell="jio_ts4_pc" lib="IO_CELLS_JIC3V" view="cmos_sch"
	config cell="DECAP5JI3V" lib="D_CELLS_JI3V" view="cmos_sch"
	config cell="DECAP7JI3V" lib="D_CELLS_JI3V" view="cmos_sch"
	config cell="rdn3" view="analogtext"
	config cell="jio_resp_pc" lib="IO_CELLS_JIC3V" view="cmos_sch"
	config cell="ICPC" lib="IO_CELLS_JIC3V" view="cmos_sch"
	config cell="dnpdd_scr" view="analogtext"
	config cell="rnp1" view="analogtext"
	config cell="HVDD4D2PK" lib="HV_CELLS" view="schematic"
	config cell="DFRQJI3VX1" lib="D_CELLS_JI3V" view="cmos_sch"
	config cell="jio_ne3i_pc" lib="IO_CELLS_JIC3V" view="cmos_sch"
	config cell="inv_hv" lib="INV_HV" view="schematic"
	config cell="BT4PC" lib="IO_CELLS_JIC3V" view="cmos_sch"
	config cell="jio_ne3is_pc" lib="IO_CELLS_JIC3V" view="cmos_sch"
	config cell="vsource" view="analogtext"
	config cell="dn3" view="analogtext"
	config cell="pmb" view="analogtext"
	config cell="invrji3v" lib="GATES_JI3V" view="schematic"
	config cell="jio_esd1_pc" lib="IO_CELLS_JIC3V" view="cmos_sch"
	config cell="ioh_d2pk" lib="HV_CELLS" view="schematic"
	config cell="PSUBPADPC" lib="IO_CELLS_JIC3V" view="cmos_sch"
	config cell="DECAP25JI3V" lib="D_CELLS_JI3V" view="cmos_sch"
	config cell="HVD4SJD1R5PKFs" lib="HV_CELLS" view="schematic"
	config cell="AN21JI3VX1" lib="D_CELLS_JI3V" view="cmos_sch"
	config cell="ioh_pmbsabhv_750" lib="HV_CELLS" view="schematic"
	config cell="dpdd_scr" view="analogtext"
	config cell="DLY2JI3VX1" lib="D_CELLS_JI3V" view="cmos_sch"
	config cell="ioh_pmbsab_40_10" lib="HV_CELLS" view="schematic"
	config cell="ioh_pe3isab_15_04" lib="HV_CELLS" view="schematic"
	config cell="ioring3" lib="IORING" view="schematic"
	config cell="BUJI3VX1" lib="D_CELLS_JI3V" view="cmos_sch"
	config cell="DECAP15JI3V" lib="D_CELLS_JI3V" view="cmos_sch"
	config cell="dphnw" view="analogtext"
	config cell="jio_anrdio_pc" lib="IO_CELLS_JIC3V" view="cmos_sch"
	config cell="GNDPADPC" lib="IO_CELLS_JIC3V" view="cmos_sch"
	config cell="counter" lib="COUNTER_JI3" view="schematic"
	config cell="ddnwmv" view="analogtext"
	config cell="ioh_pe3isabhv_2800gcr" lib="HV_CELLS" view="schematic"
	config cell="PWRCUTDCPC" lib="IO_CELLS_JIC3V" view="cmos_sch"
	config cell="ioh_dhpw_2x100_stack3" lib="HV_CELLS" view="schematic"
	config cell="s_res" view="analogtext"
	config cell="DFRQJI3VX4" lib="D_CELLS_JI3V" view="cmos_sch"
	config cell="ioh_dhpw_2x100" lib="HV_CELLS" view="schematic"
	config cell="ioh_d5pk" lib="HV_CELLS" view="schematic"
	config cell="BUJI3VX2" lib="D_CELLS_JI3V" view="cmos_sch"
	config cell="a22no2ji3v" lib="GATES_JI3V" view="schematic"
	config cell="rdp3" view="analogtext"
	config cell="jio_andio_pc" lib="IO_CELLS_JIC3V" view="cmos_sch"
	config cell="ne3" view="analogtext"
	config cell="jio_ipdio_pc" lib="IO_CELLS_JIC3V" view="cmos_sch"
	config cell="dhpw" view="analogtext"
	config cell="VDDPADPC" lib="IO_CELLS_JIC3V" view="cmos_sch"
	config cell="ioh_c5pk" lib="HV_CELLS" view="schematic"
	config cell="VDDORPADPC" lib="IO_CELLS_JIC3V" view="cmos_sch"
	config cell="HVDD4DJ5PKFs" lib="HV_CELLS" view="schematic"
	config cell="ioh_pmbsabhv_2000" lib="HV_CELLS" view="schematic"
	config cell="a2no2ji3v" lib="GATES_JI3V" view="schematic"
	config cell="EN2JI3VX0" lib="D_CELLS_JI3V" view="cmos_sch"
	config cell="jio_ndtr_pc" lib="IO_CELLS_JIC3V" view="cmos_sch"
	config cell="jio_tsctrl_pc" lib="IO_CELLS_JIC3V" view="cmos_sch"
	config cell="APR00DPC" lib="IO_CELLS_JIC3V" view="cmos_sch"
	config cell="pe3i" view="analogtext"

 }
