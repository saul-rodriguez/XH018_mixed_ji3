// Verilog-AMS cds_globals module for top-level cell:
//    TOP/top_tb.
// Generated by ADE.
// Cadence Design Systems, Inc.

// This is an autoGenerated file, any changes done to this file may get lost.

`include "disciplines.vams"
`include "userDisciplines.vams"

module cds_globals;

// Global Signals
   wire \gnd3i! ;
   wire \vdd3i! ;
   electrical \gnd! ;
   ground \gnd! ;

// Design Variables
   dynamicparam real temperature = 27;

endmodule
