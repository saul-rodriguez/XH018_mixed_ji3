// -----------------------------------------------------------------------------
// (c) Copyright 2010 Cadence Design Systems, Inc. All rights reserved worldwide.
// -----------------------------------------------------------------------------

// Binding AMSD Control Block for config TOP.top_tb:config_sch
// Created On: Feb  9 05:16:39 2024
// NOTE      : DO NOT change this system generated file.

amsd {
	config designtop="TOP.top_tb:schematic"

	config cell="counter" lib="COUNTER_JI3" view="functional"
	config cell="jio_ne3is_pc" lib="IO_CELLS_JIC3V" view="cmos_sch"
	config cell="ddnwmv" view="analogtext"
	config cell="ioh_pe3isabhv_2800gcr" lib="HV_CELLS" view="schematic"
	config cell="vsource" view="analogtext"
	config cell="PWRCUTDCPC" lib="IO_CELLS_JIC3V" view="cmos_sch"
	config cell="ioring" lib="IORING" view="schematic"
	config cell="top" lib="TOP" view="schematic"
	config cell="ioh_dhpw_2x100_stack3" lib="HV_CELLS" view="schematic"
	config cell="ne3i" view="analogtext"
	config cell="dn3" view="analogtext"
	config cell="pmb" view="analogtext"
	config cell="ioh_dhpw_2x100" lib="HV_CELLS" view="schematic"
	config cell="ioh_d5pk" lib="HV_CELLS" view="schematic"
	config cell="jio_esd1_pc" lib="IO_CELLS_JIC3V" view="cmos_sch"
	config cell="ioh_pmbsab_15_10" lib="HV_CELLS" view="schematic"
	config cell="rdp3" view="analogtext"
	config cell="rpp1" view="analogtext"
	config cell="jio_andio_pc" lib="IO_CELLS_JIC3V" view="cmos_sch"
	config cell="ioh_d2pk" lib="HV_CELLS" view="schematic"
	config cell="ne3" view="analogtext"
	config cell="dipdnwmv" view="analogtext"
	config cell="jio_pe3i_pc" lib="IO_CELLS_JIC3V" view="cmos_sch"
	config cell="jio_opdio_pc" lib="IO_CELLS_JIC3V" view="cmos_sch"
	config cell="jio_ipdio_pc" lib="IO_CELLS_JIC3V" view="cmos_sch"
	config cell="GNDORPADPC" lib="IO_CELLS_JIC3V" view="cmos_sch"
	config cell="dhpw" view="analogtext"
	config cell="rpp1s" view="analogtext"
	config cell="VDDPADPC" lib="IO_CELLS_JIC3V" view="cmos_sch"
	config cell="PSUBPADPC" lib="IO_CELLS_JIC3V" view="cmos_sch"
	config cell="rpp1k1_3" view="analogtext"
	config cell="jio_bufc_pc" lib="IO_CELLS_JIC3V" view="cmos_sch"
	config cell="inv" lib="INV_LP" view="schematic"
	config cell="ioh_c5pk" lib="HV_CELLS" view="schematic"
	config cell="rdp_io" view="analogtext"
	config cell="HVD4SJD1R5PKFs" lib="HV_CELLS" view="schematic"
	config cell="ioh_pe3isabhv_1050gcr" lib="HV_CELLS" view="schematic"
	config cell="ioh_iscrd2_4x100" lib="HV_CELLS" view="schematic"
	config cell="dpdnw" view="analogtext"
	config cell="VDDORPADPC" lib="IO_CELLS_JIC3V" view="cmos_sch"
	config cell="ioh_pmbsabhv_750" lib="HV_CELLS" view="schematic"
	config cell="dpdd_scr" view="analogtext"
	config cell="dp3" view="analogtext"
	config cell="APR04DPC" lib="IO_CELLS_JIC3V" view="cmos_sch"
	config cell="ioh_pmbsab_40_10" lib="HV_CELLS" view="schematic"
	config cell="jio_tp4_pc" lib="IO_CELLS_JIC3V" view="cmos_sch"
	config cell="jio_ts4_pc" lib="IO_CELLS_JIC3V" view="cmos_sch"
	config cell="ioh_pe3isab_15_04" lib="HV_CELLS" view="schematic"
	config cell="HVDD4DJ5PKFs" lib="HV_CELLS" view="schematic"
	config cell="resistor" view="analogtext"
	config cell="rdn3" view="analogtext"
	config cell="ioh_pmbsabhv_2000" lib="HV_CELLS" view="schematic"
	config cell="ICPC" lib="IO_CELLS_JIC3V" view="cmos_sch"
	config cell="jio_resp_pc" lib="IO_CELLS_JIC3V" view="cmos_sch"
	config cell="jio_ndtr_pc" lib="IO_CELLS_JIC3V" view="cmos_sch"
	config cell="dphnw" view="analogtext"
	config cell="nedia" view="analogtext"
	config cell="pe3" view="analogtext"
	config cell="dnpdd_scr" view="analogtext"
	config cell="rnp1" view="analogtext"
	config cell="ioh_pe3isab_40_04" lib="HV_CELLS" view="schematic"
	config cell="HVDD4D2PK" lib="HV_CELLS" view="schematic"
	config cell="jio_tsctrl_pc" lib="IO_CELLS_JIC3V" view="cmos_sch"
	config cell="ddnw" view="analogtext"
	config cell="APR00DPC" lib="IO_CELLS_JIC3V" view="cmos_sch"
	config cell="jio_anrdio_pc" lib="IO_CELLS_JIC3V" view="cmos_sch"
	config cell="inv_hv" lib="INV_HV" view="schematic"
	config cell="jio_ne3i_pc" lib="IO_CELLS_JIC3V" view="cmos_sch"
	config cell="jio_lviodio_pc" lib="IO_CELLS_JIC3V" view="cmos_sch"
	config cell="counter_stimulus" lib="COUNTER_JI3" view="verilogams"
	config cell="BT4PC" lib="IO_CELLS_JIC3V" view="cmos_sch"
	config cell="GNDPADPC" lib="IO_CELLS_JIC3V" view="cmos_sch"
	config cell="pe3i" view="analogtext"

 }
