// AMS netlist generated by the AMS Unified netlister
// IC subversion:  IC6.1.8-64b.500.34
// Xcelium version: 23.09-s002
// Copyright(C) 2005-2009, Cadence Design Systems, Inc
// User: saul Pid: 17969
// Design library name: TOP
// Design cell name: top_tb
// Design view name: config_sch
// Solver: Spectre

`include "disciplines.vams"
`include "userDisciplines.vams"
// HDL file - COUNTER_JI3, counter_stimulus, verilogams.
// Library - COUNTER_JI3, Cell - counter, View - schematic
// LAST TIME SAVED: Feb  3 16:10:44 2024
// NETLIST TIME: Feb 12 01:23:42 2024

`worklib COUNTER_JI3
`view schematic

`timescale 1ns / 1ps
(* cds_ams_schematic *)

module counter (out, enable, clk, reset);
input  clk, enable, reset;
output [7:0] out;
wire n_1;
wire n_6;
wire n_5;
wire n_0;
wire n_2;
wire n_7;
wire n_3;
wire n_12;
wire n_15;
wire FE_OFN0_out_0;
wire n_10;
wire n_29;
wire n_32;
wire n_25;
wire n_28;
wire n_17;
wire n_20;
wire n_21;
wire n_24;
wire FE_PHN2_enable;
wire FE_PHN5_n_22;
wire n_22;
wire FE_PHN4_n_18;
wire n_18;
wire FE_PHN3_n_14;
wire n_14;
wire FE_PHN1_reset;
wire FE_PHN10_n_38;
wire n_38;
wire CTS_1;
wire CTS_2;
wire n_36;
wire n_9;
wire n_33;
wire FE_PHN9_n_37;
wire FE_PHN8_n_34;
wire FE_PHN6_n_26;
wire FE_PHN7_n_30;
wire n_19;
wire n_13;
wire n_35;
wire n_37;
wire n_31;
wire n_34;
wire n_23;
wire n_26;
wire n_27;
wire n_30;
NA2JI3VX0 g225__6417 (.B( n_6 ), .Q( n_1 ), .A( out[2] ));
NA2JI3VX0 g222__2346 (.B( n_6 ), .Q( n_5 ), .A( out[1] ));
NA2JI3VX0 g224__5477 (.B( n_6 ), .Q( n_0 ), .A( out[6] ));
NA2JI3VX0 g226__7410 (.B( n_6 ), .Q( n_2 ), .A( out[5] ));
NA2JI3VX0 g221__2883 (.B( n_6 ), .Q( n_7 ), .A( out[3] ));
NA2JI3VX0 g223__1666 (.B( n_6 ), .Q( n_3 ), .A( out[4] ));
NA2JI3VX0 g217__9315 (.B( out[2] ), .Q( n_15 ), .A( n_12 ));
NA2JI3VX0 g227__2398 (.B( out[1] ), .Q( n_10 ), .A( FE_OFN0_out_0 ));
NA2JI3VX0 g197__1617 (.B( out[6] ), .Q( n_32 ), .A( n_29 ));
NA2JI3VX0 g202__5122 (.B( out[5] ), .Q( n_28 ), .A( n_25 ));
NA2JI3VX0 g212__7482 (.B( out[3] ), .Q( n_20 ), .A( n_17 ));
NA2JI3VX0 g207__6131 (.B( out[4] ), .Q( n_24 ), .A( n_21 ));
INJI3VX0 g218 (.A( n_10 ), .Q( n_12 ));
INJI3VX0 g213 (.A( n_15 ), .Q( n_17 ));
INJI3VX0 g232 (.A( FE_PHN2_enable ), .Q( n_6 ));
INJI3VX0 g198 (.A( n_28 ), .Q( n_29 ));
INJI3VX0 g203 (.A( n_24 ), .Q( n_25 ));
INJI3VX0 g208 (.A( n_20 ), .Q( n_21 ));
DLY2JI3VX1 FE_PHC5_n_22 (.A( n_22 ), .Q( FE_PHN5_n_22 ));
DLY2JI3VX1 FE_PHC4_n_18 (.A( n_18 ), .Q( FE_PHN4_n_18 ));
DLY2JI3VX1 FE_PHC3_n_14 (.A( n_14 ), .Q( FE_PHN3_n_14 ));
DLY2JI3VX1 FE_PHC2_enable (.A( enable ), .Q( FE_PHN2_enable ));
DLY2JI3VX1 FE_PHC1_reset (.A( reset ), .Q( FE_PHN1_reset ));
BUJI3VX2 FE_PHC10_n_38 (.A( n_38 ), .Q( FE_PHN10_n_38 ));
BUJI3VX2 FE_OFC0_out_0 (.A( FE_OFN0_out_0 ), .Q( out[0] ));
DECAP5JI3V FILLCAP_T_1_6 ();
DECAP5JI3V FILLCAP_T_1_8 ();
DECAP5JI3V FILLCAP_T_1_10 ();
DECAP5JI3V FILLCAP_T_1_12 ();
DECAP5JI3V FILLCAP_T_1_17 ();
DECAP5JI3V FILLCAP_T_1_21 ();
DECAP5JI3V FILLCAP_T_1_24 ();
DECAP5JI3V FILLCAP_T_1_30 ();
DECAP5JI3V FILLCAP_T_1_34 ();
DECAP5JI3V FILLCAP_T_1_35 ();
DECAP5JI3V FILLCAP_T_1_38 ();
DECAP7JI3V FILLCAP_T_1_3 ();
DECAP7JI3V FILLCAP_T_1_13 ();
DECAP7JI3V FILLCAP_T_1_14 ();
DECAP7JI3V FILLCAP_T_1_15 ();
DECAP7JI3V FILLCAP_T_1_16 ();
DECAP7JI3V FILLCAP_T_1_18 ();
DECAP7JI3V FILLCAP_T_1_19 ();
DECAP7JI3V FILLCAP_T_1_20 ();
DECAP7JI3V FILLCAP_T_1_22 ();
DECAP7JI3V FILLCAP_T_1_25 ();
DECAP7JI3V FILLCAP_T_1_26 ();
DECAP7JI3V FILLCAP_T_1_27 ();
DECAP7JI3V FILLCAP_T_1_28 ();
DECAP7JI3V FILLCAP_T_1_29 ();
DECAP7JI3V FILLCAP_T_1_31 ();
DECAP7JI3V FILLCAP_T_1_32 ();
DECAP7JI3V FILLCAP_T_1_33 ();
DECAP7JI3V FILLCAP_T_1_37 ();
DECAP10JI3V FILLCAP_T_1_2 ();
DECAP10JI3V FILLCAP_T_1_4 ();
DECAP10JI3V FILLCAP_T_1_9 ();
DECAP10JI3V FILLCAP_T_1_23 ();
DECAP10JI3V FILLCAP_T_1_36 ();
DECAP15JI3V FILLCAP_T_1_5 ();
DECAP15JI3V FILLCAP_T_1_7 ();
DECAP15JI3V FILLCAP_T_1_11 ();
DECAP25JI3V FILLCAP_T_1_1 ();
BUJI3VX1 CTS_cdb_buf_00009 (.A( CTS_2 ), .Q( CTS_1 ));
BUJI3VX1 CTS_cdb_buf_00010 (.A( clk ), .Q( CTS_2 ));
DFRQJI3VX1 \out_reg[0]  (.Q( FE_OFN0_out_0 ), .D( FE_PHN3_n_14 ), .C( CTS_1 ));
NO2JI3VX0 g187__2398 (.B( n_36 ), .A( FE_PHN1_reset ), .Q( n_38 ));
NO2JI3VX0 g219__4733 (.B( n_9 ), .A( FE_PHN1_reset ), .Q( n_14 ));
EN2JI3VX0 g191__5526 (.A( out[7] ), .B( n_32 ), .Q( n_33 ));
EN2JI3VX0 g220__9945 (.A( FE_PHN2_enable ), .B( FE_OFN0_out_0 ), .Q( n_9 ));
DFRQJI3VX2 \out_reg[2]  (.Q( out[2] ), .D( FE_PHN5_n_22 ), .C( CTS_1 ));
DFRQJI3VX2 \out_reg[6]  (.Q( out[6] ), .D( FE_PHN9_n_37 ), .C( CTS_1 ));
DFRQJI3VX2 \out_reg[5]  (.Q( out[5] ), .D( FE_PHN8_n_34 ), .C( CTS_1 ));
DFRQJI3VX2 \out_reg[3]  (.Q( out[3] ), .D( FE_PHN6_n_26 ), .C( CTS_1 ));
DFRQJI3VX2 \out_reg[4]  (.Q( out[4] ), .D( FE_PHN7_n_30 ), .C( CTS_1 ));
DFRQJI3VX2 \out_reg[7]  (.Q( out[7] ), .D( FE_PHN10_n_38 ), .C( CTS_1 ));
AN22JI3VX1 g189__6260 (.Q( n_36 ), .D( n_6 ), .C( out[7] ), .A( n_33 ), .B( FE_PHN2_enable ));
AN21JI3VX1 g209__7098 (.Q( n_22 ), .C( FE_PHN1_reset ), .A( n_19 ), .B( n_1 ));
AN21JI3VX1 g214__5115 (.Q( n_18 ), .C( FE_PHN1_reset ), .A( n_13 ), .B( n_5 ));
AN21JI3VX1 g190__5107 (.Q( n_37 ), .C( FE_PHN1_reset ), .A( n_35 ), .B( n_0 ));
AN21JI3VX1 g194__8428 (.Q( n_34 ), .C( FE_PHN1_reset ), .A( n_31 ), .B( n_2 ));
AN21JI3VX1 g204__1705 (.Q( n_26 ), .C( FE_PHN1_reset ), .A( n_23 ), .B( n_7 ));
AN21JI3VX1 g199__3680 (.Q( n_30 ), .C( FE_PHN1_reset ), .A( n_27 ), .B( n_3 ));
DLY1JI3VX1 FE_PHC6_n_26 (.A( n_26 ), .Q( FE_PHN6_n_26 ));
DLY1JI3VX1 FE_PHC7_n_30 (.A( n_30 ), .Q( FE_PHN7_n_30 ));
ON211JI3VX1 g211__1881 (.D( FE_PHN2_enable ), .Q( n_19 ), .C( n_15 ), .A( n_12 ), .B( out[2] ));
ON211JI3VX1 g216__6161 (.D( FE_PHN2_enable ), .Q( n_13 ), .C( n_10 ), .A( out[0] ), .B( out[1] ));
ON211JI3VX1 g193__4319 (.D( FE_PHN2_enable ), .Q( n_35 ), .C( n_32 ), .A( n_29 ), .B( out[6] ));
ON211JI3VX1 g196__6783 (.D( FE_PHN2_enable ), .Q( n_31 ), .C( n_28 ), .A( n_25 ), .B( out[5] ));
ON211JI3VX1 g206__8246 (.D( FE_PHN2_enable ), .Q( n_23 ), .C( n_20 ), .A( n_17 ), .B( out[3] ));
ON211JI3VX1 g201__2802 (.D( FE_PHN2_enable ), .Q( n_27 ), .C( n_24 ), .A( n_21 ), .B( out[4] ));
BUJI3VX16 FE_PHC8_n_34 (.A( n_34 ), .Q( FE_PHN8_n_34 ));
BUJI3VX0 FE_PHC9_n_37 (.A( n_37 ), .Q( FE_PHN9_n_37 ));
DFRQJI3VX4 \out_reg[1]  (.Q( out[1] ), .D( FE_PHN4_n_18 ), .C( CTS_1 ));

endmodule
// Library - GATES_JI3V, Cell - nor2ji3v, View - schematic
// LAST TIME SAVED: Mar  5 10:08:46 2018
// NETLIST TIME: Feb 12 01:23:42 2024

`worklib GATES_JI3V
`view schematic

`timescale 1ns / 1ps
(* cds_ams_schematic *)

module nor2ji3v (out, a, b);
output  out;
input  a, b;
wire (*
integer inh_conn_prop_name = "power_vdd3i";
integer inh_conn_def_value = "cds_globals.\\vdd3i! "; *)
\vdd3i! ;
wire (*
integer inh_conn_prop_name = "ground_gnd3i";
integer inh_conn_def_value = "cds_globals.\\gnd3i! "; *)
\gnd3i! ;
parameter GT_PUW=0 ;
parameter GT_PUL=3e-07 ;
parameter GT_PDW=0 ;
parameter GT_PDL=3.5e-07 ;
pe3i #(.w(GT_PUW), .l(GT_PUL), .as(4.8e-07*(GT_PUW)), .ad(4.8e-07*(GT_PUW)), .ps(1*2*(4.8e-07+(GT_PUW))), .pd(2*(4.8e-07+(GT_PUW))), .nrs(2.7e-07/(GT_PUW)), .nrd(2.7e-07/(GT_PUW)), .m((1)*(1)), .par1((1)*(1)))
(* integer passed_mfactor = "m"; *)
 MP1 (out, a, net32, \vdd3i! );
pe3i #(.w(GT_PUW), .l(GT_PUL), .as(4.8e-07*(GT_PUW)), .ad(4.8e-07*(GT_PUW)), .ps(1*2*(4.8e-07+(GT_PUW))), .pd(2*(4.8e-07+(GT_PUW))), .nrs(2.7e-07/(GT_PUW)), .nrd(2.7e-07/(GT_PUW)), .m((1)*(1)), .par1((1)*(1)))
(* integer passed_mfactor = "m"; *)
 MP2 (net32, b, \vdd3i! , \vdd3i! );
ne3i #(.w(GT_PDW), .l(GT_PDL), .as(4.8e-07*(GT_PDW)), .ad(4.8e-07*(GT_PDW)), .ps(1*2*(4.8e-07+(GT_PDW))), .pd(2*(4.8e-07+(GT_PDW))), .nrs(2.7e-07/(GT_PDW)), .nrd(2.7e-07/(GT_PDW)), .m((1)*(1)), .par1((1)*(1)))
(* integer passed_mfactor = "m"; *)
 MN1 (out, b, \gnd3i! , \gnd3i! );
ne3i #(.w(GT_PDW), .l(GT_PDL), .as(4.8e-07*(GT_PDW)), .ad(4.8e-07*(GT_PDW)), .ps(1*2*(4.8e-07+(GT_PDW))), .pd(2*(4.8e-07+(GT_PDW))), .nrs(2.7e-07/(GT_PDW)), .nrd(2.7e-07/(GT_PDW)), .m((1)*(1)), .par1((1)*(1)))
(* integer passed_mfactor = "m"; *)
 MN2 (out, a, \gnd3i! , \gnd3i! );

endmodule
// Library - GATES_JI3V, Cell - o2na2ji3v, View - schematic
// LAST TIME SAVED: Jul 13 06:45:27 2022
// NETLIST TIME: Feb 12 01:23:42 2024

`worklib GATES_JI3V
`view schematic

`timescale 1ns / 1ps
(* cds_ams_schematic *)

module o2na2ji3v (out, a, b, c);
output  out;
input  a, b, c;
wire (*
integer inh_conn_prop_name = "power_vdd3i";
integer inh_conn_def_value = "cds_globals.\\vdd3i! "; *)
\vdd3i! ;
wire (*
integer inh_conn_prop_name = "ground_gnd3i";
integer inh_conn_def_value = "cds_globals.\\gnd3i! "; *)
\gnd3i! ;
parameter GT_PDW=0 ;
parameter GT_PDL=3.5e-07 ;
parameter GT_PUW=0 ;
parameter GT_PUL=3e-07 ;
ne3i #(.w(GT_PDW), .l(GT_PDL), .as(4.8e-07*(GT_PDW)), .ad(4.8e-07*(GT_PDW)), .ps(1*2*(4.8e-07+(GT_PDW))), .pd(2*(4.8e-07+(GT_PDW))), .nrs(2.7e-07/(GT_PDW)), .nrd(2.7e-07/(GT_PDW)), .m((1)*(1)), .par1((1)*(1)))
(* integer passed_mfactor = "m"; *)
 MN2 (net7, b, \gnd3i! , \gnd3i! );
ne3i #(.w(GT_PDW), .l(GT_PDL), .as(4.8e-07*(GT_PDW)), .ad(4.8e-07*(GT_PDW)), .ps(1*2*(4.8e-07+(GT_PDW))), .pd(2*(4.8e-07+(GT_PDW))), .nrs(2.7e-07/(GT_PDW)), .nrd(2.7e-07/(GT_PDW)), .m((1)*(1)), .par1((1)*(1)))
(* integer passed_mfactor = "m"; *)
 MN1 (net7, a, \gnd3i! , \gnd3i! );
ne3i #(.w(GT_PDW), .l(GT_PDL), .as(4.8e-07*(GT_PDW)), .ad(4.8e-07*(GT_PDW)), .ps(1*2*(4.8e-07+(GT_PDW))), .pd(2*(4.8e-07+(GT_PDW))), .nrs(2.7e-07/(GT_PDW)), .nrd(2.7e-07/(GT_PDW)), .m((1)*(1)), .par1((1)*(1)))
(* integer passed_mfactor = "m"; *)
 MN3 (out, c, net7, \gnd3i! );
pe3i #(.w(GT_PUW), .l(GT_PUL), .as(4.8e-07*(GT_PUW)), .ad(4.8e-07*(GT_PUW)), .ps(1*2*(4.8e-07+(GT_PUW))), .pd(2*(4.8e-07+(GT_PUW))), .nrs(2.7e-07/(GT_PUW)), .nrd(2.7e-07/(GT_PUW)), .m((1)*(1)), .par1((1)*(1)))
(* integer passed_mfactor = "m"; *)
 MP1 (out, a, net17, \vdd3i! );
pe3i #(.w(0.7*GT_PUW), .l(GT_PUL), .as(4.8e-07*(0.7*GT_PUW)), .ad(4.8e-07*(0.7*GT_PUW)), .ps(1*2*(4.8e-07+(0.7*GT_PUW))), .pd(2*(4.8e-07+(0.7*GT_PUW))), .nrs(2.7e-07/(0.7*GT_PUW)), .nrd(2.7e-07/(0.7*GT_PUW)), .m((1)*(1)), .par1((1)*(1)))
(* integer passed_mfactor = "m"; *)
 MP3 (out, c, \vdd3i! , \vdd3i! );
pe3i #(.w(GT_PUW), .l(GT_PUL), .as(4.8e-07*(GT_PUW)), .ad(4.8e-07*(GT_PUW)), .ps(1*2*(4.8e-07+(GT_PUW))), .pd(2*(4.8e-07+(GT_PUW))), .nrs(2.7e-07/(GT_PUW)), .nrd(2.7e-07/(GT_PUW)), .m((1)*(1)), .par1((1)*(1)))
(* integer passed_mfactor = "m"; *)
 MP2 (net17, b, \vdd3i! , \vdd3i! );

endmodule
// Library - GATES_JI3V, Cell - nand2ji3v, View - schematic
// LAST TIME SAVED: Mar  5 10:07:48 2018
// NETLIST TIME: Feb 12 01:23:42 2024

`worklib GATES_JI3V
`view schematic

`timescale 1ns / 1ps
(* cds_ams_schematic *)

module nand2ji3v (out, a, b);
output  out;
input  a, b;
wire (*
integer inh_conn_prop_name = "power_vdd3i";
integer inh_conn_def_value = "cds_globals.\\vdd3i! "; *)
\vdd3i! ;
wire (*
integer inh_conn_prop_name = "ground_gnd3i";
integer inh_conn_def_value = "cds_globals.\\gnd3i! "; *)
\gnd3i! ;
parameter GT_PUW=0 ;
parameter GT_PUL=3e-07 ;
parameter GT_PDW=0 ;
parameter GT_PDL=3.5e-07 ;
pe3i #(.w(GT_PUW), .l(GT_PUL), .as(4.8e-07*(GT_PUW)), .ad(4.8e-07*(GT_PUW)), .ps(1*2*(4.8e-07+(GT_PUW))), .pd(2*(4.8e-07+(GT_PUW))), .nrs(2.7e-07/(GT_PUW)), .nrd(2.7e-07/(GT_PUW)), .m((1)*(1)), .par1((1)*(1)))
(* integer passed_mfactor = "m"; *)
 MP1 (out, a, \vdd3i! , \vdd3i! );
pe3i #(.w(GT_PUW), .l(GT_PUL), .as(4.8e-07*(GT_PUW)), .ad(4.8e-07*(GT_PUW)), .ps(1*2*(4.8e-07+(GT_PUW))), .pd(2*(4.8e-07+(GT_PUW))), .nrs(2.7e-07/(GT_PUW)), .nrd(2.7e-07/(GT_PUW)), .m((1)*(1)), .par1((1)*(1)))
(* integer passed_mfactor = "m"; *)
 MP2 (out, b, \vdd3i! , \vdd3i! );
ne3i #(.w(GT_PDW), .l(GT_PDL), .as(4.8e-07*(GT_PDW)), .ad(4.8e-07*(GT_PDW)), .ps(1*2*(4.8e-07+(GT_PDW))), .pd(2*(4.8e-07+(GT_PDW))), .nrs(2.7e-07/(GT_PDW)), .nrd(2.7e-07/(GT_PDW)), .m((1)*(1)), .par1((1)*(1)))
(* integer passed_mfactor = "m"; *)
 MN1 (out, a, net25, \gnd3i! );
ne3i #(.w(GT_PDW), .l(GT_PDL), .as(4.8e-07*(GT_PDW)), .ad(4.8e-07*(GT_PDW)), .ps(1*2*(4.8e-07+(GT_PDW))), .pd(2*(4.8e-07+(GT_PDW))), .nrs(2.7e-07/(GT_PDW)), .nrd(2.7e-07/(GT_PDW)), .m((1)*(1)), .par1((1)*(1)))
(* integer passed_mfactor = "m"; *)
 MN2 (net25, b, \gnd3i! , \gnd3i! );

endmodule
// Library - GATES_JI3V, Cell - a22no2ji3v, View - schematic
// LAST TIME SAVED: Jul 13 05:17:52 2022
// NETLIST TIME: Feb 12 01:23:42 2024

`worklib GATES_JI3V
`view schematic

`timescale 1ns / 1ps
(* cds_ams_schematic *)

module a22no2ji3v (out, a, b, c, d);
output  out;
input  a, b, c, d;
wire (*
integer inh_conn_prop_name = "power_vdd3i";
integer inh_conn_def_value = "cds_globals.\\vdd3i! "; *)
\vdd3i! ;
wire (*
integer inh_conn_prop_name = "ground_gnd3i";
integer inh_conn_def_value = "cds_globals.\\gnd3i! "; *)
\gnd3i! ;
parameter GT_PDW=0 ;
parameter GT_PDL=3.5e-07 ;
parameter GT_PUW=0 ;
parameter GT_PUL=3e-07 ;
ne3i #(.w(GT_PDW), .l(GT_PDL), .as(4.8e-07*(GT_PDW)), .ad(4.8e-07*(GT_PDW)), .ps(1*2*(4.8e-07+(GT_PDW))), .pd(2*(4.8e-07+(GT_PDW))), .nrs(2.7e-07/(GT_PDW)), .nrd(2.7e-07/(GT_PDW)), .m((1)*(1)), .par1((1)*(1)))
(* integer passed_mfactor = "m"; *)
 MN1 (out, a, net21, \gnd3i! );
ne3i #(.w(GT_PDW), .l(GT_PDL), .as(4.8e-07*(GT_PDW)), .ad(4.8e-07*(GT_PDW)), .ps(1*2*(4.8e-07+(GT_PDW))), .pd(2*(4.8e-07+(GT_PDW))), .nrs(2.7e-07/(GT_PDW)), .nrd(2.7e-07/(GT_PDW)), .m((1)*(1)), .par1((1)*(1)))
(* integer passed_mfactor = "m"; *)
 MN2 (net21, b, \gnd3i! , \gnd3i! );
ne3i #(.w(GT_PDW), .l(GT_PDL), .as(4.8e-07*(GT_PDW)), .ad(4.8e-07*(GT_PDW)), .ps(1*2*(4.8e-07+(GT_PDW))), .pd(2*(4.8e-07+(GT_PDW))), .nrs(2.7e-07/(GT_PDW)), .nrd(2.7e-07/(GT_PDW)), .m((1)*(1)), .par1((1)*(1)))
(* integer passed_mfactor = "m"; *)
 MN3 (out, c, net22, \gnd3i! );
ne3i #(.w(GT_PDW), .l(GT_PDL), .as(4.8e-07*(GT_PDW)), .ad(4.8e-07*(GT_PDW)), .ps(1*2*(4.8e-07+(GT_PDW))), .pd(2*(4.8e-07+(GT_PDW))), .nrs(2.7e-07/(GT_PDW)), .nrd(2.7e-07/(GT_PDW)), .m((1)*(1)), .par1((1)*(1)))
(* integer passed_mfactor = "m"; *)
 MN4 (net22, d, \gnd3i! , \gnd3i! );
pe3i #(.w(GT_PUW), .l(GT_PUL), .as(4.8e-07*(GT_PUW)), .ad(4.8e-07*(GT_PUW)), .ps(1*2*(4.8e-07+(GT_PUW))), .pd(2*(4.8e-07+(GT_PUW))), .nrs(2.7e-07/(GT_PUW)), .nrd(2.7e-07/(GT_PUW)), .m((1)*(1)), .par1((1)*(1)))
(* integer passed_mfactor = "m"; *)
 MP1 (net11, a, \vdd3i! , \vdd3i! );
pe3i #(.w(GT_PUW), .l(GT_PUL), .as(4.8e-07*(GT_PUW)), .ad(4.8e-07*(GT_PUW)), .ps(1*2*(4.8e-07+(GT_PUW))), .pd(2*(4.8e-07+(GT_PUW))), .nrs(2.7e-07/(GT_PUW)), .nrd(2.7e-07/(GT_PUW)), .m((1)*(1)), .par1((1)*(1)))
(* integer passed_mfactor = "m"; *)
 MP2 (net11, b, \vdd3i! , \vdd3i! );
pe3i #(.w(GT_PUW), .l(GT_PUL), .as(4.8e-07*(GT_PUW)), .ad(4.8e-07*(GT_PUW)), .ps(1*2*(4.8e-07+(GT_PUW))), .pd(2*(4.8e-07+(GT_PUW))), .nrs(2.7e-07/(GT_PUW)), .nrd(2.7e-07/(GT_PUW)), .m((1)*(1)), .par1((1)*(1)))
(* integer passed_mfactor = "m"; *)
 MP4 (out, d, net11, \vdd3i! );
pe3i #(.w(GT_PUW), .l(GT_PUL), .as(4.8e-07*(GT_PUW)), .ad(4.8e-07*(GT_PUW)), .ps(1*2*(4.8e-07+(GT_PUW))), .pd(2*(4.8e-07+(GT_PUW))), .nrs(2.7e-07/(GT_PUW)), .nrd(2.7e-07/(GT_PUW)), .m((1)*(1)), .par1((1)*(1)))
(* integer passed_mfactor = "m"; *)
 MP3 (out, c, net11, \vdd3i! );

endmodule
// Library - GATES_JI3V, Cell - a2no2ji3v, View - schematic
// LAST TIME SAVED: Jul 13 05:11:00 2022
// NETLIST TIME: Feb 12 01:23:42 2024

`worklib GATES_JI3V
`view schematic

`timescale 1ns / 1ps
(* cds_ams_schematic *)

module a2no2ji3v (out, a, b, c);
output  out;
input  a, b, c;
wire (*
integer inh_conn_prop_name = "power_vdd3i";
integer inh_conn_def_value = "cds_globals.\\vdd3i! "; *)
\vdd3i! ;
wire (*
integer inh_conn_prop_name = "ground_gnd3i";
integer inh_conn_def_value = "cds_globals.\\gnd3i! "; *)
\gnd3i! ;
parameter GT_PDW=0 ;
parameter GT_PDL=3.5e-07 ;
parameter GT_PUW=0 ;
parameter GT_PUL=3e-07 ;
ne3i #(.w(GT_PDW), .l(GT_PDL), .as(4.8e-07*(GT_PDW)), .ad(4.8e-07*(GT_PDW)), .ps(1*2*(4.8e-07+(GT_PDW))), .pd(2*(4.8e-07+(GT_PDW))), .nrs(2.7e-07/(GT_PDW)), .nrd(2.7e-07/(GT_PDW)), .m((1)*(1)), .par1((1)*(1)))
(* integer passed_mfactor = "m"; *)
 MN2 (net41, b, \gnd3i! , \gnd3i! );
ne3i #(.w(GT_PDW), .l(GT_PDL), .as(4.8e-07*(GT_PDW)), .ad(4.8e-07*(GT_PDW)), .ps(1*2*(4.8e-07+(GT_PDW))), .pd(2*(4.8e-07+(GT_PDW))), .nrs(2.7e-07/(GT_PDW)), .nrd(2.7e-07/(GT_PDW)), .m((1)*(1)), .par1((1)*(1)))
(* integer passed_mfactor = "m"; *)
 MN1 (out, a, net41, \gnd3i! );
ne3i #(.w(0.75*GT_PDW), .l(GT_PDL), .as(4.8e-07*(0.75*GT_PDW)), .ad(4.8e-07*(0.75*GT_PDW)), .ps(1*2*(4.8e-07+(0.75*GT_PDW))), .pd(2*(4.8e-07+(0.75*GT_PDW))), .nrs(2.7e-07/(0.75*GT_PDW)), .nrd(2.7e-07/(0.75*GT_PDW)), .m((1)*(1)), .par1((1)*(1)))
(* integer passed_mfactor = "m"; *)
 MN3 (out, c, \gnd3i! , \gnd3i! );
pe3i #(.w(GT_PUW), .l(GT_PUL), .as(4.8e-07*(GT_PUW)), .ad(4.8e-07*(GT_PUW)), .ps(1*2*(4.8e-07+(GT_PUW))), .pd(2*(4.8e-07+(GT_PUW))), .nrs(2.7e-07/(GT_PUW)), .nrd(2.7e-07/(GT_PUW)), .m((1)*(1)), .par1((1)*(1)))
(* integer passed_mfactor = "m"; *)
 MP1 (net54, a, \vdd3i! , \vdd3i! );
pe3i #(.w(GT_PUW), .l(GT_PUL), .as(4.8e-07*(GT_PUW)), .ad(4.8e-07*(GT_PUW)), .ps(1*2*(4.8e-07+(GT_PUW))), .pd(2*(4.8e-07+(GT_PUW))), .nrs(2.7e-07/(GT_PUW)), .nrd(2.7e-07/(GT_PUW)), .m((1)*(1)), .par1((1)*(1)))
(* integer passed_mfactor = "m"; *)
 MP2 (net54, b, \vdd3i! , \vdd3i! );
pe3i #(.w(GT_PUW), .l(GT_PUL), .as(4.8e-07*(GT_PUW)), .ad(4.8e-07*(GT_PUW)), .ps(1*2*(4.8e-07+(GT_PUW))), .pd(2*(4.8e-07+(GT_PUW))), .nrs(2.7e-07/(GT_PUW)), .nrd(2.7e-07/(GT_PUW)), .m((1)*(1)), .par1((1)*(1)))
(* integer passed_mfactor = "m"; *)
 MP3 (out, c, net54, \vdd3i! );

endmodule
// Library - GATES_JI3V, Cell - o2na3ji3v, View - schematic
// LAST TIME SAVED: Mar  5 10:10:29 2018
// NETLIST TIME: Feb 12 01:23:42 2024

`worklib GATES_JI3V
`view schematic

`timescale 1ns / 1ps
(* cds_ams_schematic *)

module o2na3ji3v (out, a, b, c, d);
output  out;
input  a, b, c, d;
wire (*
integer inh_conn_prop_name = "power_vdd3i";
integer inh_conn_def_value = "cds_globals.\\vdd3i! "; *)
\vdd3i! ;
wire (*
integer inh_conn_prop_name = "ground_gnd3i";
integer inh_conn_def_value = "cds_globals.\\gnd3i! "; *)
\gnd3i! ;
parameter GT_PDW=0 ;
parameter GT_PDL=3.5e-07 ;
parameter GT_PUW=0 ;
parameter GT_PUL=3e-07 ;
ne3i #(.w(GT_PDW), .l(GT_PDL), .as(4.8e-07*(GT_PDW)), .ad(4.8e-07*(GT_PDW)), .ps(1*2*(4.8e-07+(GT_PDW))), .pd(2*(4.8e-07+(GT_PDW))), .nrs(2.7e-07/(GT_PDW)), .nrd(2.7e-07/(GT_PDW)), .m((1)*(1)), .par1((1)*(1)))
(* integer passed_mfactor = "m"; *)
 MN2 (out, b, net10, \gnd3i! );
ne3i #(.w(GT_PDW), .l(GT_PDL), .as(4.8e-07*(GT_PDW)), .ad(4.8e-07*(GT_PDW)), .ps(1*2*(4.8e-07+(GT_PDW))), .pd(2*(4.8e-07+(GT_PDW))), .nrs(2.7e-07/(GT_PDW)), .nrd(2.7e-07/(GT_PDW)), .m((1)*(1)), .par1((1)*(1)))
(* integer passed_mfactor = "m"; *)
 MN1 (out, a, net10, \gnd3i! );
ne3i #(.w(GT_PDW), .l(GT_PDL), .as(4.8e-07*(GT_PDW)), .ad(4.8e-07*(GT_PDW)), .ps(1*2*(4.8e-07+(GT_PDW))), .pd(2*(4.8e-07+(GT_PDW))), .nrs(2.7e-07/(GT_PDW)), .nrd(2.7e-07/(GT_PDW)), .m((1)*(1)), .par1((1)*(1)))
(* integer passed_mfactor = "m"; *)
 MN3 (net10, c, net25, \gnd3i! );
ne3i #(.w(GT_PDW), .l(GT_PDL), .as(4.8e-07*(GT_PDW)), .ad(4.8e-07*(GT_PDW)), .ps(1*2*(4.8e-07+(GT_PDW))), .pd(2*(4.8e-07+(GT_PDW))), .nrs(2.7e-07/(GT_PDW)), .nrd(2.7e-07/(GT_PDW)), .m((1)*(1)), .par1((1)*(1)))
(* integer passed_mfactor = "m"; *)
 MN4 (net25, d, \gnd3i! , \gnd3i! );
pe3i #(.w(0.7*GT_PUW), .l(GT_PUL), .as(4.8e-07*(0.7*GT_PUW)), .ad(4.8e-07*(0.7*GT_PUW)), .ps(1*2*(4.8e-07+(0.7*GT_PUW))), .pd(2*(4.8e-07+(0.7*GT_PUW))), .nrs(2.7e-07/(0.7*GT_PUW)), .nrd(2.7e-07/(0.7*GT_PUW)), .m((1)*(1)), .par1((1)*(1)))
(* integer passed_mfactor = "m"; *)
 MP4 (out, d, \vdd3i! , \vdd3i! );
pe3i #(.w(GT_PUW), .l(GT_PUL), .as(4.8e-07*(GT_PUW)), .ad(4.8e-07*(GT_PUW)), .ps(1*2*(4.8e-07+(GT_PUW))), .pd(2*(4.8e-07+(GT_PUW))), .nrs(2.7e-07/(GT_PUW)), .nrd(2.7e-07/(GT_PUW)), .m((1)*(1)), .par1((1)*(1)))
(* integer passed_mfactor = "m"; *)
 MP2 (net24, b, \vdd3i! , \vdd3i! );
pe3i #(.w(GT_PUW), .l(GT_PUL), .as(4.8e-07*(GT_PUW)), .ad(4.8e-07*(GT_PUW)), .ps(1*2*(4.8e-07+(GT_PUW))), .pd(2*(4.8e-07+(GT_PUW))), .nrs(2.7e-07/(GT_PUW)), .nrd(2.7e-07/(GT_PUW)), .m((1)*(1)), .par1((1)*(1)))
(* integer passed_mfactor = "m"; *)
 MP1 (out, a, net24, \vdd3i! );
pe3i #(.w(0.7*GT_PUW), .l(GT_PUL), .as(4.8e-07*(0.7*GT_PUW)), .ad(4.8e-07*(0.7*GT_PUW)), .ps(1*2*(4.8e-07+(0.7*GT_PUW))), .pd(2*(4.8e-07+(0.7*GT_PUW))), .nrs(2.7e-07/(0.7*GT_PUW)), .nrd(2.7e-07/(0.7*GT_PUW)), .m((1)*(1)), .par1((1)*(1)))
(* integer passed_mfactor = "m"; *)
 MP3 (out, c, \vdd3i! , \vdd3i! );

endmodule
// Library - GATES_JI3V, Cell - invrji3v, View - schematic
// LAST TIME SAVED: Jul 13 06:42:51 2022
// NETLIST TIME: Feb 12 01:23:42 2024

`worklib GATES_JI3V
`view schematic

`timescale 1ns / 1ps
(* cds_ams_schematic *)

module invrji3v (out, in);
output  out;
input  in;
wire (*
integer inh_conn_prop_name = "power_vdd3i";
integer inh_conn_def_value = "cds_globals.\\vdd3i! "; *)
\vdd3i! ;
wire (*
integer inh_conn_prop_name = "ground_gnd3i";
integer inh_conn_def_value = "cds_globals.\\gnd3i! "; *)
\gnd3i! ;
parameter GT_PUW=0 ;
parameter GT_PUL=3e-07 ;
parameter GT_PDW=0 ;
parameter GT_PDL=3.5e-07 ;
pe3i #(.w(GT_PUW), .l(GT_PUL), .as(4.8e-07*(GT_PUW)), .ad(4.8e-07*(GT_PUW)), .ps(1*2*(4.8e-07+(GT_PUW))), .pd(2*(4.8e-07+(GT_PUW))), .nrs(2.7e-07/(GT_PUW)), .nrd(2.7e-07/(GT_PUW)), .m((1)*(1)), .par1((1)*(1)))
(* integer passed_mfactor = "m"; *)
 MP1 (out, in, \vdd3i! , \vdd3i! );
ne3i #(.w(GT_PDW), .l(GT_PDL), .as(4.8e-07*(GT_PDW)), .ad(4.8e-07*(GT_PDW)), .ps(1*2*(4.8e-07+(GT_PDW))), .pd(2*(4.8e-07+(GT_PDW))), .nrs(2.7e-07/(GT_PDW)), .nrd(2.7e-07/(GT_PDW)), .m((1)*(1)), .par1((1)*(1)))
(* integer passed_mfactor = "m"; *)
 MN1 (out, in, \gnd3i! , \gnd3i! );

endmodule
// Library - IO_CELLS_JIC3V, Cell - jio_pe3i_pc, View - cmos_sch
// LAST TIME SAVED: Nov 16 11:13:44 2021
// NETLIST TIME: Feb 12 01:23:42 2024

`worklib IO_CELLS_JIC3V
`view cmos_sch

`timescale 1ns / 1ps
(* cds_ams_schematic *)

module jio_pe3i_pc (B, D, G, S);
inout  B, D, G, S;
pe3i #(.w(3e-05), .l(3.5e-07), .as(1.44e-11), .ad(1.44e-11), .ps(6.096e-05), .pd(6.096e-05), .nrs(0.009), .nrd(0.009), .m((1)*(1)), .par1((1)*(1)))
(* integer passed_mfactor = "m"; *)
 M0 (net6, G, S, B);
rdp3 #(.l(2.15e-06), .w(3e-05), .m(1), .par1(1))
(* integer passed_mfactor = "m"; *)
 R1 (net6, D, B);

endmodule
// Library - IO_CELLS_JIC3V, Cell - jio_ne3i_pc, View - cmos_sch
// LAST TIME SAVED: Nov 16 11:08:58 2021
// NETLIST TIME: Feb 12 01:23:42 2024

`worklib IO_CELLS_JIC3V
`view cmos_sch

`timescale 1ns / 1ps
(* cds_ams_schematic *)

module jio_ne3i_pc (B, D, G, S);
inout  B, D, G, S;
dn3 #(.area(9.9e-12), .perimeter(6.6e-07), .dbv(0), .m(1), .par1(1), .xf_subext(0))
(* integer passed_mfactor = "m"; *)
 D3 (B, D);
rdn3 #(.l(3.35e-06), .w(3e-05), .m(1), .par1(1), .xf_subext(0))
(* integer passed_mfactor = "m"; *)
 R0 (D, net6, B);
ne3i #(.w(3e-05), .l(4e-07), .as(1.44e-11), .ad(1.44e-11), .ps(6.096e-05), .pd(6.096e-05), .nrs(0.009), .nrd(0.009), .m((1)*(1)), .par1((1)*(1)))
(* integer passed_mfactor = "m"; *)
 M0 (net6, G, S, B);

endmodule
// Library - IO_CELLS_JIC3V, Cell - jio_andio_pc, View - cmos_sch
// LAST TIME SAVED: Nov 16 02:00:22 2021
// NETLIST TIME: Feb 12 01:23:42 2024

`worklib IO_CELLS_JIC3V
`view cmos_sch

`timescale 1ns / 1ps
(* cds_ams_schematic *)

module jio_andio_pc (DNW, PSUB, PWI);
input  DNW, PSUB, PWI;
ddnwmv #(.area(4.69976e-09), .perimeter(0.00027464), .dbv(0), .m(1), .par1(1), .xf_subext(0))
(* integer passed_mfactor = "m"; *)
 D3 (PSUB, DNW);
dipdnwmv #(.area(4.16648e-09), .perimeter(0.00025864), .dbv(0), .m(1), .par1(1))
(* integer passed_mfactor = "m"; *)
 D1 (PWI, DNW);

endmodule
// Library - IO_CELLS_JIC3V, Cell - PSUBPADPC, View - cmos_sch
// LAST TIME SAVED: Nov 16 11:01:31 2021
// NETLIST TIME: Feb 12 01:23:42 2024

`worklib IO_CELLS_JIC3V
`view cmos_sch

`timescale 1ns / 1ps
(* cds_ams_schematic *)

module PSUBPADPC (GNDI, GNDOI, GNDRI, PSUB, VDD3I, VDDOI, VDDRI);
input  GNDI, GNDOI, GNDRI, PSUB, VDD3I, VDDOI, VDDRI;
wire pg;
wire ng;
jio_pe3i_pc IP_1 (.S( VDDOI ), .G( pg ), .B( VDDOI ), .D( PSUB ));
jio_pe3i_pc IP_2 (.S( VDDOI ), .G( pg ), .B( VDDOI ), .D( PSUB ));
jio_pe3i_pc IP_3 (.S( VDDOI ), .G( pg ), .B( VDDOI ), .D( PSUB ));
jio_pe3i_pc IP_4 (.S( VDDOI ), .G( pg ), .B( VDDOI ), .D( PSUB ));
jio_pe3i_pc IP_5 (.S( VDDOI ), .G( pg ), .B( VDDOI ), .D( PSUB ));
jio_pe3i_pc IP_6 (.S( VDDOI ), .G( pg ), .B( VDDOI ), .D( PSUB ));
jio_pe3i_pc IP_7 (.S( VDDOI ), .G( pg ), .B( VDDOI ), .D( PSUB ));
jio_pe3i_pc IP_8 (.S( VDDOI ), .G( pg ), .B( VDDOI ), .D( PSUB ));
jio_pe3i_pc IP_9 (.S( VDDOI ), .G( pg ), .B( VDDOI ), .D( PSUB ));
jio_pe3i_pc IP_10 (.S( VDDOI ), .G( pg ), .B( VDDOI ), .D( PSUB ));
jio_pe3i_pc IP_11 (.S( VDDOI ), .G( pg ), .B( VDDOI ), .D( PSUB ));
jio_pe3i_pc IP_12 (.S( VDDOI ), .G( pg ), .B( VDDOI ), .D( PSUB ));
jio_pe3i_pc IP_13 (.S( VDDOI ), .G( pg ), .B( VDDOI ), .D( PSUB ));
jio_pe3i_pc IP_14 (.S( VDDOI ), .G( pg ), .B( VDDOI ), .D( PSUB ));
jio_pe3i_pc IP_15 (.S( VDDOI ), .G( pg ), .B( VDDOI ), .D( PSUB ));
jio_pe3i_pc IP_16 (.S( VDDOI ), .G( pg ), .B( VDDOI ), .D( PSUB ));
jio_pe3i_pc IP_17 (.S( VDDOI ), .G( pg ), .B( VDDOI ), .D( PSUB ));
jio_pe3i_pc IP_18 (.S( VDDOI ), .G( pg ), .B( VDDOI ), .D( PSUB ));
jio_pe3i_pc IP_19 (.S( VDDOI ), .G( pg ), .B( VDDOI ), .D( PSUB ));
jio_pe3i_pc IP_20 (.S( VDDOI ), .G( pg ), .B( VDDOI ), .D( PSUB ));
jio_pe3i_pc IP_21 (.S( VDDOI ), .G( pg ), .B( VDDOI ), .D( PSUB ));
jio_pe3i_pc IP_22 (.S( VDDOI ), .G( pg ), .B( VDDOI ), .D( PSUB ));
jio_pe3i_pc IP_23 (.S( VDDOI ), .G( pg ), .B( VDDOI ), .D( PSUB ));
jio_pe3i_pc IP_24 (.S( VDDOI ), .G( pg ), .B( VDDOI ), .D( PSUB ));
jio_pe3i_pc IP_25 (.S( VDDOI ), .G( pg ), .B( VDDOI ), .D( PSUB ));
jio_pe3i_pc IP_26 (.S( VDDOI ), .G( pg ), .B( VDDOI ), .D( PSUB ));
jio_pe3i_pc IP_27 (.S( VDDOI ), .G( pg ), .B( VDDOI ), .D( PSUB ));
jio_pe3i_pc IP_28 (.S( VDDOI ), .G( pg ), .B( VDDOI ), .D( PSUB ));
jio_pe3i_pc IP_29 (.S( VDDOI ), .G( pg ), .B( VDDOI ), .D( PSUB ));
jio_pe3i_pc IP_30 (.S( VDDOI ), .G( pg ), .B( VDDOI ), .D( PSUB ));
jio_pe3i_pc IP_31 (.S( VDDOI ), .G( pg ), .B( VDDOI ), .D( PSUB ));
jio_pe3i_pc IP_32 (.S( VDDOI ), .G( pg ), .B( VDDOI ), .D( PSUB ));
jio_ne3i_pc IN_1 (.D( GNDOI ), .B( PSUB ), .G( ng ), .S( PSUB ));
jio_ne3i_pc IN_2 (.D( GNDOI ), .B( PSUB ), .G( ng ), .S( PSUB ));
jio_ne3i_pc IN_3 (.D( GNDOI ), .B( PSUB ), .G( ng ), .S( PSUB ));
jio_ne3i_pc IN_4 (.D( GNDOI ), .B( PSUB ), .G( ng ), .S( PSUB ));
jio_ne3i_pc IN_5 (.D( GNDOI ), .B( PSUB ), .G( ng ), .S( PSUB ));
jio_ne3i_pc IN_6 (.D( GNDOI ), .B( PSUB ), .G( ng ), .S( PSUB ));
jio_ne3i_pc IN_7 (.D( GNDOI ), .B( PSUB ), .G( ng ), .S( PSUB ));
jio_ne3i_pc IN_8 (.D( GNDOI ), .B( PSUB ), .G( ng ), .S( PSUB ));
jio_ne3i_pc IN_9 (.D( GNDOI ), .B( PSUB ), .G( ng ), .S( PSUB ));
jio_ne3i_pc IN_10 (.D( GNDOI ), .B( PSUB ), .G( ng ), .S( PSUB ));
jio_ne3i_pc IN_11 (.D( GNDOI ), .B( PSUB ), .G( ng ), .S( PSUB ));
jio_ne3i_pc IN_12 (.D( GNDOI ), .B( PSUB ), .G( ng ), .S( PSUB ));
jio_ne3i_pc IN_13 (.D( GNDOI ), .B( PSUB ), .G( ng ), .S( PSUB ));
jio_ne3i_pc IN_14 (.D( GNDOI ), .B( PSUB ), .G( ng ), .S( PSUB ));
jio_ne3i_pc IN_15 (.D( GNDOI ), .B( PSUB ), .G( ng ), .S( PSUB ));
jio_ne3i_pc IN_16 (.D( GNDOI ), .B( PSUB ), .G( ng ), .S( PSUB ));
jio_ne3i_pc IN_17 (.D( GNDOI ), .B( PSUB ), .G( ng ), .S( PSUB ));
jio_ne3i_pc IN_18 (.D( GNDOI ), .B( PSUB ), .G( ng ), .S( PSUB ));
jio_ne3i_pc IN_19 (.D( GNDOI ), .B( PSUB ), .G( ng ), .S( PSUB ));
jio_ne3i_pc IN_20 (.D( GNDOI ), .B( PSUB ), .G( ng ), .S( PSUB ));
jio_ne3i_pc IN_21 (.D( GNDOI ), .B( PSUB ), .G( ng ), .S( PSUB ));
jio_ne3i_pc IN_22 (.D( GNDOI ), .B( PSUB ), .G( ng ), .S( PSUB ));
jio_ne3i_pc IN_23 (.D( GNDOI ), .B( PSUB ), .G( ng ), .S( PSUB ));
jio_ne3i_pc IN_24 (.D( GNDOI ), .B( PSUB ), .G( ng ), .S( PSUB ));
jio_andio_pc I157 (.PSUB( PSUB ), .PWI( PSUB ), .DNW( GNDOI ));
rdp3 #(.l(3.3e-06), .w(4.4e-07), .m(1), .par1(1))
(* integer passed_mfactor = "m"; *)
 R11 (ng, PSUB, VDDOI);
rdp3 #(.l(3.3e-06), .w(4.4e-07), .m(1), .par1(1))
(* integer passed_mfactor = "m"; *)
 R0 (VDDOI, pg, VDDOI);

endmodule
// Library - IO_CELLS_JIC3V, Cell - VDDPADPC, View - cmos_sch
// LAST TIME SAVED: Nov 16 11:05:21 2021
// NETLIST TIME: Feb 12 01:23:42 2024

`worklib IO_CELLS_JIC3V
`view cmos_sch

`timescale 1ns / 1ps
(* cds_ams_schematic *)

module VDDPADPC (GNDI, GNDOI, GNDRI, PSUB, VDD3I, VDDOI, VDDRI);
input  GNDI, GNDOI, GNDRI, PSUB, VDD3I, VDDOI, VDDRI;
wire ng;
wire pg;
jio_ne3i_pc IN_1 (.D( VDD3I ), .B( GNDOI ), .G( ng ), .S( GNDOI ));
jio_ne3i_pc IN_2 (.D( VDD3I ), .B( GNDOI ), .G( ng ), .S( GNDOI ));
jio_ne3i_pc IN_3 (.D( VDD3I ), .B( GNDOI ), .G( ng ), .S( GNDOI ));
jio_ne3i_pc IN_4 (.D( VDD3I ), .B( GNDOI ), .G( ng ), .S( GNDOI ));
jio_ne3i_pc IN_5 (.D( VDD3I ), .B( GNDOI ), .G( ng ), .S( GNDOI ));
jio_ne3i_pc IN_6 (.D( VDD3I ), .B( GNDOI ), .G( ng ), .S( GNDOI ));
jio_ne3i_pc IN_7 (.D( VDD3I ), .B( GNDOI ), .G( ng ), .S( GNDOI ));
jio_ne3i_pc IN_8 (.D( VDD3I ), .B( GNDOI ), .G( ng ), .S( GNDOI ));
jio_ne3i_pc IN_9 (.D( VDD3I ), .B( GNDOI ), .G( ng ), .S( GNDOI ));
jio_ne3i_pc IN_10 (.D( VDD3I ), .B( GNDOI ), .G( ng ), .S( GNDOI ));
jio_ne3i_pc IN_11 (.D( VDD3I ), .B( GNDOI ), .G( ng ), .S( GNDOI ));
jio_ne3i_pc IN_12 (.D( VDD3I ), .B( GNDOI ), .G( ng ), .S( GNDOI ));
jio_ne3i_pc IN_13 (.D( VDD3I ), .B( GNDOI ), .G( ng ), .S( GNDOI ));
jio_ne3i_pc IN_14 (.D( VDD3I ), .B( GNDOI ), .G( ng ), .S( GNDOI ));
jio_ne3i_pc IN_15 (.D( VDD3I ), .B( GNDOI ), .G( ng ), .S( GNDOI ));
jio_ne3i_pc IN_16 (.D( VDD3I ), .B( GNDOI ), .G( ng ), .S( GNDOI ));
jio_ne3i_pc IN_17 (.D( VDD3I ), .B( GNDOI ), .G( ng ), .S( GNDOI ));
jio_ne3i_pc IN_18 (.D( VDD3I ), .B( GNDOI ), .G( ng ), .S( GNDOI ));
jio_ne3i_pc IN_19 (.D( VDD3I ), .B( GNDOI ), .G( ng ), .S( GNDOI ));
jio_ne3i_pc IN_20 (.D( VDD3I ), .B( GNDOI ), .G( ng ), .S( GNDOI ));
jio_ne3i_pc IN_21 (.D( VDD3I ), .B( GNDOI ), .G( ng ), .S( GNDOI ));
jio_ne3i_pc IN_22 (.D( VDD3I ), .B( GNDOI ), .G( ng ), .S( GNDOI ));
jio_ne3i_pc IN_23 (.D( VDD3I ), .B( GNDOI ), .G( ng ), .S( GNDOI ));
jio_ne3i_pc IN_24 (.D( VDD3I ), .B( GNDOI ), .G( ng ), .S( GNDOI ));
jio_andio_pc I157 (.DNW( VDDOI ), .PWI( GNDOI ), .PSUB( PSUB ));
jio_pe3i_pc IP_1 (.S( VDDOI ), .G( pg ), .B( VDDOI ), .D( VDD3I ));
jio_pe3i_pc IP_2 (.S( VDDOI ), .G( pg ), .B( VDDOI ), .D( VDD3I ));
jio_pe3i_pc IP_3 (.S( VDDOI ), .G( pg ), .B( VDDOI ), .D( VDD3I ));
jio_pe3i_pc IP_4 (.S( VDDOI ), .G( pg ), .B( VDDOI ), .D( VDD3I ));
jio_pe3i_pc IP_5 (.S( VDDOI ), .G( pg ), .B( VDDOI ), .D( VDD3I ));
jio_pe3i_pc IP_6 (.S( VDDOI ), .G( pg ), .B( VDDOI ), .D( VDD3I ));
jio_pe3i_pc IP_7 (.S( VDDOI ), .G( pg ), .B( VDDOI ), .D( VDD3I ));
jio_pe3i_pc IP_8 (.S( VDDOI ), .G( pg ), .B( VDDOI ), .D( VDD3I ));
jio_pe3i_pc IP_9 (.S( VDDOI ), .G( pg ), .B( VDDOI ), .D( VDD3I ));
jio_pe3i_pc IP_10 (.S( VDDOI ), .G( pg ), .B( VDDOI ), .D( VDD3I ));
jio_pe3i_pc IP_11 (.S( VDDOI ), .G( pg ), .B( VDDOI ), .D( VDD3I ));
jio_pe3i_pc IP_12 (.S( VDDOI ), .G( pg ), .B( VDDOI ), .D( VDD3I ));
jio_pe3i_pc IP_13 (.S( VDDOI ), .G( pg ), .B( VDDOI ), .D( VDD3I ));
jio_pe3i_pc IP_14 (.S( VDDOI ), .G( pg ), .B( VDDOI ), .D( VDD3I ));
jio_pe3i_pc IP_15 (.S( VDDOI ), .G( pg ), .B( VDDOI ), .D( VDD3I ));
jio_pe3i_pc IP_16 (.S( VDDOI ), .G( pg ), .B( VDDOI ), .D( VDD3I ));
jio_pe3i_pc IP_17 (.S( VDDOI ), .G( pg ), .B( VDDOI ), .D( VDD3I ));
jio_pe3i_pc IP_18 (.S( VDDOI ), .G( pg ), .B( VDDOI ), .D( VDD3I ));
jio_pe3i_pc IP_19 (.S( VDDOI ), .G( pg ), .B( VDDOI ), .D( VDD3I ));
jio_pe3i_pc IP_20 (.S( VDDOI ), .G( pg ), .B( VDDOI ), .D( VDD3I ));
jio_pe3i_pc IP_21 (.S( VDDOI ), .G( pg ), .B( VDDOI ), .D( VDD3I ));
jio_pe3i_pc IP_22 (.S( VDDOI ), .G( pg ), .B( VDDOI ), .D( VDD3I ));
jio_pe3i_pc IP_23 (.S( VDDOI ), .G( pg ), .B( VDDOI ), .D( VDD3I ));
jio_pe3i_pc IP_24 (.S( VDDOI ), .G( pg ), .B( VDDOI ), .D( VDD3I ));
jio_pe3i_pc IP_25 (.S( VDDOI ), .G( pg ), .B( VDDOI ), .D( VDD3I ));
jio_pe3i_pc IP_26 (.S( VDDOI ), .G( pg ), .B( VDDOI ), .D( VDD3I ));
jio_pe3i_pc IP_27 (.S( VDDOI ), .G( pg ), .B( VDDOI ), .D( VDD3I ));
jio_pe3i_pc IP_28 (.S( VDDOI ), .G( pg ), .B( VDDOI ), .D( VDD3I ));
jio_pe3i_pc IP_29 (.S( VDDOI ), .G( pg ), .B( VDDOI ), .D( VDD3I ));
jio_pe3i_pc IP_30 (.S( VDDOI ), .G( pg ), .B( VDDOI ), .D( VDD3I ));
jio_pe3i_pc IP_31 (.S( VDDOI ), .G( pg ), .B( VDDOI ), .D( VDD3I ));
jio_pe3i_pc IP_32 (.S( VDDOI ), .G( pg ), .B( VDDOI ), .D( VDD3I ));
rdp3 #(.l(3.3e-06), .w(4.4e-07), .m(1), .par1(1))
(* integer passed_mfactor = "m"; *)
 R0 (VDDOI, pg, VDDOI);
rdp3 #(.l(3.3e-06), .w(4.4e-07), .m(1), .par1(1))
(* integer passed_mfactor = "m"; *)
 R11 (ng, GNDOI, VDDOI);

endmodule
// Library - IO_CELLS_JIC3V, Cell - VDDORPADPC, View - cmos_sch
// LAST TIME SAVED: Nov 16 11:04:45 2021
// NETLIST TIME: Feb 12 01:23:42 2024

`worklib IO_CELLS_JIC3V
`view cmos_sch

`timescale 1ns / 1ps
(* cds_ams_schematic *)

module VDDORPADPC (GNDI, GNDOI, GNDRI, PSUB, VDD3I, VDDORI);
input  GNDI, GNDOI, GNDRI, PSUB, VDD3I, VDDORI;
wire ng;
jio_ne3i_pc IN_1 (.D( VDDORI ), .B( GNDOI ), .G( ng ), .S( GNDOI ));
jio_ne3i_pc IN_2 (.D( VDDORI ), .B( GNDOI ), .G( ng ), .S( GNDOI ));
jio_ne3i_pc IN_3 (.D( VDDORI ), .B( GNDOI ), .G( ng ), .S( GNDOI ));
jio_ne3i_pc IN_4 (.D( VDDORI ), .B( GNDOI ), .G( ng ), .S( GNDOI ));
jio_ne3i_pc IN_5 (.D( VDDORI ), .B( GNDOI ), .G( ng ), .S( GNDOI ));
jio_ne3i_pc IN_6 (.D( VDDORI ), .B( GNDOI ), .G( ng ), .S( GNDOI ));
jio_ne3i_pc IN_7 (.D( VDDORI ), .B( GNDOI ), .G( ng ), .S( GNDOI ));
jio_ne3i_pc IN_8 (.D( VDDORI ), .B( GNDOI ), .G( ng ), .S( GNDOI ));
jio_ne3i_pc IN_9 (.D( VDDORI ), .B( GNDOI ), .G( ng ), .S( GNDOI ));
jio_ne3i_pc IN_10 (.D( VDDORI ), .B( GNDOI ), .G( ng ), .S( GNDOI ));
jio_ne3i_pc IN_11 (.D( VDDORI ), .B( GNDOI ), .G( ng ), .S( GNDOI ));
jio_ne3i_pc IN_12 (.D( VDDORI ), .B( GNDOI ), .G( ng ), .S( GNDOI ));
jio_ne3i_pc IN_13 (.D( VDDORI ), .B( GNDOI ), .G( ng ), .S( GNDOI ));
jio_ne3i_pc IN_14 (.D( VDDORI ), .B( GNDOI ), .G( ng ), .S( GNDOI ));
jio_ne3i_pc IN_15 (.D( VDDORI ), .B( GNDOI ), .G( ng ), .S( GNDOI ));
jio_ne3i_pc IN_16 (.D( VDDORI ), .B( GNDOI ), .G( ng ), .S( GNDOI ));
jio_ne3i_pc IN_17 (.D( VDDORI ), .B( GNDOI ), .G( ng ), .S( GNDOI ));
jio_ne3i_pc IN_18 (.D( VDDORI ), .B( GNDOI ), .G( ng ), .S( GNDOI ));
jio_ne3i_pc IN_19 (.D( VDDORI ), .B( GNDOI ), .G( ng ), .S( GNDOI ));
jio_ne3i_pc IN_20 (.D( VDDORI ), .B( GNDOI ), .G( ng ), .S( GNDOI ));
jio_ne3i_pc IN_21 (.D( VDDORI ), .B( GNDOI ), .G( ng ), .S( GNDOI ));
jio_ne3i_pc IN_22 (.D( VDDORI ), .B( GNDOI ), .G( ng ), .S( GNDOI ));
jio_ne3i_pc IN_23 (.D( VDDORI ), .B( GNDOI ), .G( ng ), .S( GNDOI ));
jio_ne3i_pc IN_24 (.D( VDDORI ), .B( GNDOI ), .G( ng ), .S( GNDOI ));
jio_andio_pc I157 (.DNW( VDDORI ), .PWI( GNDOI ), .PSUB( PSUB ));
rdp3 #(.l(3.3e-06), .w(4.4e-07), .m(1), .par1(1))
(* integer passed_mfactor = "m"; *)
 R11 (ng, GNDOI, VDDORI);

endmodule
// Library - IO_CELLS_JIC3V, Cell - GNDPADPC, View - cmos_sch
// LAST TIME SAVED: Nov 16 11:00:33 2021
// NETLIST TIME: Feb 12 01:23:42 2024

`worklib IO_CELLS_JIC3V
`view cmos_sch

`timescale 1ns / 1ps
(* cds_ams_schematic *)

module GNDPADPC (GNDI, GNDOI, GNDRI, PSUB, VDD3I, VDDOI, VDDRI);
input  GNDI, GNDOI, GNDRI, PSUB, VDD3I, VDDOI, VDDRI;
wire ng;
wire pg;
jio_ne3i_pc IN_1 (.D( GNDI ), .B( GNDOI ), .G( ng ), .S( GNDOI ));
jio_ne3i_pc IN_2 (.D( GNDI ), .B( GNDOI ), .G( ng ), .S( GNDOI ));
jio_ne3i_pc IN_3 (.D( GNDI ), .B( GNDOI ), .G( ng ), .S( GNDOI ));
jio_ne3i_pc IN_4 (.D( GNDI ), .B( GNDOI ), .G( ng ), .S( GNDOI ));
jio_ne3i_pc IN_5 (.D( GNDI ), .B( GNDOI ), .G( ng ), .S( GNDOI ));
jio_ne3i_pc IN_6 (.D( GNDI ), .B( GNDOI ), .G( ng ), .S( GNDOI ));
jio_ne3i_pc IN_7 (.D( GNDI ), .B( GNDOI ), .G( ng ), .S( GNDOI ));
jio_ne3i_pc IN_8 (.D( GNDI ), .B( GNDOI ), .G( ng ), .S( GNDOI ));
jio_ne3i_pc IN_9 (.D( GNDI ), .B( GNDOI ), .G( ng ), .S( GNDOI ));
jio_ne3i_pc IN_10 (.D( GNDI ), .B( GNDOI ), .G( ng ), .S( GNDOI ));
jio_ne3i_pc IN_11 (.D( GNDI ), .B( GNDOI ), .G( ng ), .S( GNDOI ));
jio_ne3i_pc IN_12 (.D( GNDI ), .B( GNDOI ), .G( ng ), .S( GNDOI ));
jio_ne3i_pc IN_13 (.D( GNDI ), .B( GNDOI ), .G( ng ), .S( GNDOI ));
jio_ne3i_pc IN_14 (.D( GNDI ), .B( GNDOI ), .G( ng ), .S( GNDOI ));
jio_ne3i_pc IN_15 (.D( GNDI ), .B( GNDOI ), .G( ng ), .S( GNDOI ));
jio_ne3i_pc IN_16 (.D( GNDI ), .B( GNDOI ), .G( ng ), .S( GNDOI ));
jio_ne3i_pc IN_17 (.D( GNDI ), .B( GNDOI ), .G( ng ), .S( GNDOI ));
jio_ne3i_pc IN_18 (.D( GNDI ), .B( GNDOI ), .G( ng ), .S( GNDOI ));
jio_ne3i_pc IN_19 (.D( GNDI ), .B( GNDOI ), .G( ng ), .S( GNDOI ));
jio_ne3i_pc IN_20 (.D( GNDI ), .B( GNDOI ), .G( ng ), .S( GNDOI ));
jio_ne3i_pc IN_21 (.D( GNDI ), .B( GNDOI ), .G( ng ), .S( GNDOI ));
jio_ne3i_pc IN_22 (.D( GNDI ), .B( GNDOI ), .G( ng ), .S( GNDOI ));
jio_ne3i_pc IN_23 (.D( GNDI ), .B( GNDOI ), .G( ng ), .S( GNDOI ));
jio_ne3i_pc IN_24 (.D( GNDI ), .B( GNDOI ), .G( ng ), .S( GNDOI ));
jio_andio_pc I157 (.DNW( VDDOI ), .PWI( GNDOI ), .PSUB( PSUB ));
jio_pe3i_pc IP_1 (.S( VDDOI ), .G( pg ), .B( VDDOI ), .D( GNDI ));
jio_pe3i_pc IP_2 (.S( VDDOI ), .G( pg ), .B( VDDOI ), .D( GNDI ));
jio_pe3i_pc IP_3 (.S( VDDOI ), .G( pg ), .B( VDDOI ), .D( GNDI ));
jio_pe3i_pc IP_4 (.S( VDDOI ), .G( pg ), .B( VDDOI ), .D( GNDI ));
jio_pe3i_pc IP_5 (.S( VDDOI ), .G( pg ), .B( VDDOI ), .D( GNDI ));
jio_pe3i_pc IP_6 (.S( VDDOI ), .G( pg ), .B( VDDOI ), .D( GNDI ));
jio_pe3i_pc IP_7 (.S( VDDOI ), .G( pg ), .B( VDDOI ), .D( GNDI ));
jio_pe3i_pc IP_8 (.S( VDDOI ), .G( pg ), .B( VDDOI ), .D( GNDI ));
jio_pe3i_pc IP_9 (.S( VDDOI ), .G( pg ), .B( VDDOI ), .D( GNDI ));
jio_pe3i_pc IP_10 (.S( VDDOI ), .G( pg ), .B( VDDOI ), .D( GNDI ));
jio_pe3i_pc IP_11 (.S( VDDOI ), .G( pg ), .B( VDDOI ), .D( GNDI ));
jio_pe3i_pc IP_12 (.S( VDDOI ), .G( pg ), .B( VDDOI ), .D( GNDI ));
jio_pe3i_pc IP_13 (.S( VDDOI ), .G( pg ), .B( VDDOI ), .D( GNDI ));
jio_pe3i_pc IP_14 (.S( VDDOI ), .G( pg ), .B( VDDOI ), .D( GNDI ));
jio_pe3i_pc IP_15 (.S( VDDOI ), .G( pg ), .B( VDDOI ), .D( GNDI ));
jio_pe3i_pc IP_16 (.S( VDDOI ), .G( pg ), .B( VDDOI ), .D( GNDI ));
jio_pe3i_pc IP_17 (.S( VDDOI ), .G( pg ), .B( VDDOI ), .D( GNDI ));
jio_pe3i_pc IP_18 (.S( VDDOI ), .G( pg ), .B( VDDOI ), .D( GNDI ));
jio_pe3i_pc IP_19 (.S( VDDOI ), .G( pg ), .B( VDDOI ), .D( GNDI ));
jio_pe3i_pc IP_20 (.S( VDDOI ), .G( pg ), .B( VDDOI ), .D( GNDI ));
jio_pe3i_pc IP_21 (.S( VDDOI ), .G( pg ), .B( VDDOI ), .D( GNDI ));
jio_pe3i_pc IP_22 (.S( VDDOI ), .G( pg ), .B( VDDOI ), .D( GNDI ));
jio_pe3i_pc IP_23 (.S( VDDOI ), .G( pg ), .B( VDDOI ), .D( GNDI ));
jio_pe3i_pc IP_24 (.S( VDDOI ), .G( pg ), .B( VDDOI ), .D( GNDI ));
jio_pe3i_pc IP_25 (.S( VDDOI ), .G( pg ), .B( VDDOI ), .D( GNDI ));
jio_pe3i_pc IP_26 (.S( VDDOI ), .G( pg ), .B( VDDOI ), .D( GNDI ));
jio_pe3i_pc IP_27 (.S( VDDOI ), .G( pg ), .B( VDDOI ), .D( GNDI ));
jio_pe3i_pc IP_28 (.S( VDDOI ), .G( pg ), .B( VDDOI ), .D( GNDI ));
jio_pe3i_pc IP_29 (.S( VDDOI ), .G( pg ), .B( VDDOI ), .D( GNDI ));
jio_pe3i_pc IP_30 (.S( VDDOI ), .G( pg ), .B( VDDOI ), .D( GNDI ));
jio_pe3i_pc IP_31 (.S( VDDOI ), .G( pg ), .B( VDDOI ), .D( GNDI ));
jio_pe3i_pc IP_32 (.S( VDDOI ), .G( pg ), .B( VDDOI ), .D( GNDI ));
rdp3 #(.l(3.3e-06), .w(4.4e-07), .m(1), .par1(1))
(* integer passed_mfactor = "m"; *)
 R0 (VDDOI, pg, VDDOI);
rdp3 #(.l(3.3e-06), .w(4.4e-07), .m(1), .par1(1))
(* integer passed_mfactor = "m"; *)
 R11 (ng, GNDOI, VDDOI);

endmodule
// Library - IO_CELLS_JIC3V, Cell - GNDORPADPC, View - cmos_sch
// LAST TIME SAVED: Nov 16 11:00:05 2021
// NETLIST TIME: Feb 12 01:23:42 2024

`worklib IO_CELLS_JIC3V
`view cmos_sch

`timescale 1ns / 1ps
(* cds_ams_schematic *)

module GNDORPADPC (GNDI, GNDORI, PSUB, VDD3I, VDDOI, VDDRI);
input  GNDI, GNDORI, PSUB, VDD3I, VDDOI, VDDRI;
wire ng;
jio_ne3i_pc IN_1 (.D( VDDOI ), .B( GNDORI ), .G( ng ), .S( GNDORI ));
jio_ne3i_pc IN_2 (.D( VDDOI ), .B( GNDORI ), .G( ng ), .S( GNDORI ));
jio_ne3i_pc IN_3 (.D( VDDOI ), .B( GNDORI ), .G( ng ), .S( GNDORI ));
jio_ne3i_pc IN_4 (.D( VDDOI ), .B( GNDORI ), .G( ng ), .S( GNDORI ));
jio_ne3i_pc IN_5 (.D( VDDOI ), .B( GNDORI ), .G( ng ), .S( GNDORI ));
jio_ne3i_pc IN_6 (.D( VDDOI ), .B( GNDORI ), .G( ng ), .S( GNDORI ));
jio_ne3i_pc IN_7 (.D( VDDOI ), .B( GNDORI ), .G( ng ), .S( GNDORI ));
jio_ne3i_pc IN_8 (.D( VDDOI ), .B( GNDORI ), .G( ng ), .S( GNDORI ));
jio_ne3i_pc IN_9 (.D( VDDOI ), .B( GNDORI ), .G( ng ), .S( GNDORI ));
jio_ne3i_pc IN_10 (.D( VDDOI ), .B( GNDORI ), .G( ng ), .S( GNDORI ));
jio_ne3i_pc IN_11 (.D( VDDOI ), .B( GNDORI ), .G( ng ), .S( GNDORI ));
jio_ne3i_pc IN_12 (.D( VDDOI ), .B( GNDORI ), .G( ng ), .S( GNDORI ));
jio_ne3i_pc IN_13 (.D( VDDOI ), .B( GNDORI ), .G( ng ), .S( GNDORI ));
jio_ne3i_pc IN_14 (.D( VDDOI ), .B( GNDORI ), .G( ng ), .S( GNDORI ));
jio_ne3i_pc IN_15 (.D( VDDOI ), .B( GNDORI ), .G( ng ), .S( GNDORI ));
jio_ne3i_pc IN_16 (.D( VDDOI ), .B( GNDORI ), .G( ng ), .S( GNDORI ));
jio_ne3i_pc IN_17 (.D( VDDOI ), .B( GNDORI ), .G( ng ), .S( GNDORI ));
jio_ne3i_pc IN_18 (.D( VDDOI ), .B( GNDORI ), .G( ng ), .S( GNDORI ));
jio_ne3i_pc IN_19 (.D( VDDOI ), .B( GNDORI ), .G( ng ), .S( GNDORI ));
jio_ne3i_pc IN_20 (.D( VDDOI ), .B( GNDORI ), .G( ng ), .S( GNDORI ));
jio_ne3i_pc IN_21 (.D( VDDOI ), .B( GNDORI ), .G( ng ), .S( GNDORI ));
jio_ne3i_pc IN_22 (.D( VDDOI ), .B( GNDORI ), .G( ng ), .S( GNDORI ));
jio_ne3i_pc IN_23 (.D( VDDOI ), .B( GNDORI ), .G( ng ), .S( GNDORI ));
jio_ne3i_pc IN_24 (.D( VDDOI ), .B( GNDORI ), .G( ng ), .S( GNDORI ));
jio_andio_pc I157 (.DNW( VDDOI ), .PWI( GNDORI ), .PSUB( PSUB ));
rdp3 #(.l(3.3e-06), .w(4.4e-07), .m(1), .par1(1))
(* integer passed_mfactor = "m"; *)
 R11 (ng, GNDORI, VDDOI);

endmodule
// Library - IO_CELLS_JIC3V, Cell - jio_ipdio_pc, View - cmos_sch
// LAST TIME SAVED: Nov 16 02:00:19 2021
// NETLIST TIME: Feb 12 01:23:42 2024

`worklib IO_CELLS_JIC3V
`view cmos_sch

`timescale 1ns / 1ps
(* cds_ams_schematic *)

module jio_ipdio_pc (DNWR, PSUB, PWIR);
input  DNWR, PSUB, PWIR;
ddnwmv #(.area(3.7825e-10), .perimeter(8.026e-05), .dbv(0), .m(1), .par1(1), .xf_subext(0))
(* integer passed_mfactor = "m"; *)
 D10 (PSUB, DNWR);
dipdnwmv #(.area(1.3272e-10), .perimeter(5.464e-05), .dbv(0), .m(1), .par1(1))
(* integer passed_mfactor = "m"; *)
 D9 (PWIR, DNWR);

endmodule
// Library - IO_CELLS_JIC3V, Cell - jio_lviodio_pc, View - cmos_sch
// LAST TIME SAVED: Nov 16 02:00:18 2021
// NETLIST TIME: Feb 12 01:23:42 2024

`worklib IO_CELLS_JIC3V
`view cmos_sch

`timescale 1ns / 1ps
(* cds_ams_schematic *)

module jio_lviodio_pc (DNLW, LPWI, PSUB);
input  DNLW, LPWI, PSUB;
dipdnwmv #(.area(3.2452e-10), .perimeter(0.00013264), .dbv(0), .m(1), .par1(1))
(* integer passed_mfactor = "m"; *)
 D2 (LPWI, DNLW);

endmodule
// Library - IO_CELLS_JIC3V, Cell - jio_opdio_pc, View - cmos_sch
// LAST TIME SAVED: Nov 16 02:00:11 2021
// NETLIST TIME: Feb 12 01:23:42 2024

`worklib IO_CELLS_JIC3V
`view cmos_sch

`timescale 1ns / 1ps
(* cds_ams_schematic *)

module jio_opdio_pc (DNLW, DNW, LPWI, NW, PSUB, PWI, VDN);
input  DNLW, DNW, LPWI, NW, PSUB, PWI, VDN;
jio_lviodio_pc I5 (.PSUB( PSUB ), .DNLW( DNLW ), .LPWI( LPWI ));
jio_andio_pc I0 (.DNW( VDN ), .PWI( PWI ), .PSUB( PSUB ));
ddnwmv #(.area(5.2955e-10), .perimeter(0.00010026), .dbv(0), .m(1), .par1(1), .xf_subext(0))
(* integer passed_mfactor = "m"; *)
 D0 (PSUB, DNW);
dipdnwmv #(.area(2.1664e-10), .perimeter(5.908e-05), .dbv(0), .m(1), .par1(1))
(* integer passed_mfactor = "m"; *)
 D1 (PWI, NW);
dipdnwmv #(.area(2.1664e-10), .perimeter(5.908e-05), .dbv(0), .m(1), .par1(1))
(* integer passed_mfactor = "m"; *)
 D3 (PWI, NW);
dipdnwmv #(.area(1.9592e-10), .perimeter(7.464e-05), .dbv(0), .m(1), .par1(1))
(* integer passed_mfactor = "m"; *)
 D5 (PWI, DNW);

endmodule
// Library - IO_CELLS_JIC3V, Cell - jio_ndtr_pc, View - cmos_sch
// LAST TIME SAVED: Nov 16 02:00:18 2021
// NETLIST TIME: Feb 12 01:23:42 2024

`worklib IO_CELLS_JIC3V
`view cmos_sch

`timescale 1ns / 1ps
(* cds_ams_schematic *)

module jio_ndtr_pc (PO, Y, GND, GNDR, PI, VDD, VDDR, YN);
output  PO, Y;
input  GND, GNDR, PI, VDD, VDDR, YN;
pe3i #(.w(2.4e-06), .l(3.5e-07), .as(1.152e-12), .ad(6.48e-13), .ps(5.76e-06), .pd(2.94e-06), .nrs(0.1125), .nrd(0.1125), .m((1)*(2)), .par1((1)*(2)))
(* integer passed_mfactor = "m"; *)
 M1 (net14, YN, VDD, VDD);
pe3i #(.w(2.4e-06), .l(3.5e-07), .as(8.16e-13), .ad(6.48e-13), .ps(3.88e-06), .pd(2.94e-06), .nrs(0.1125), .nrd(0.1125), .m((1)*(6)), .par1((1)*(6)))
(* integer passed_mfactor = "m"; *)
 M3 (net19, net14, VDD, VDD);
pe3i #(.w(2.4e-06), .l(3.5e-07), .as(1.152e-12), .ad(1.152e-12), .ps(5.76e-06), .pd(5.76e-06), .nrs(0.1125), .nrd(0.1125), .m((1)*(1)), .par1((1)*(1)))
(* integer passed_mfactor = "m"; *)
 M7 (PO, PI, VDD, VDD);
pe3i #(.w(2.4e-06), .l(3.5e-07), .as(1.152e-12), .ad(1.152e-12), .ps(5.76e-06), .pd(5.76e-06), .nrs(0.1125), .nrd(0.1125), .m((1)*(1)), .par1((1)*(1)))
(* integer passed_mfactor = "m"; *)
 M9 (PO, net14, VDD, VDD);
pe3i #(.w(2.4e-06), .l(3.5e-07), .as(1.152e-12), .ad(6.48e-13), .ps(5.76e-06), .pd(2.94e-06), .nrs(0.1125), .nrd(0.1125), .m((1)*(2)), .par1((1)*(2)))
(* integer passed_mfactor = "m"; *)
 M11 (net16, net14, VDD, VDD);
pe3i #(.w(2.4e-06), .l(3.5e-07), .as(7.488e-13), .ad(6.48e-13), .ps(3.504e-06), .pd(2.94e-06), .nrs(0.1125), .nrd(0.1125), .m((1)*(10)), .par1((1)*(10)))
(* integer passed_mfactor = "m"; *)
 M5 (Y, net19, VDD, VDD);
ne3i #(.w(1.2e-06), .l(4e-07), .as(5.76e-13), .ad(3.24e-13), .ps(3.36e-06), .pd(1.74e-06), .nrs(0.225), .nrd(0.225), .m((1)*(2)), .par1((1)*(2)))
(* integer passed_mfactor = "m"; *)
 M2 (net14, YN, GND, GND);
ne3i #(.w(1.68e-06), .l(4e-07), .as(5.712e-13), .ad(4.536e-13), .ps(2.92e-06), .pd(2.22e-06), .nrs(0.160714), .nrd(0.160714), .m((1)*(6)), .par1((1)*(6)))
(* integer passed_mfactor = "m"; *)
 M6 (Y, net16, GND, GND);
ne3i #(.w(1.68e-06), .l(4e-07), .as(8.064e-13), .ad(8.064e-13), .ps(4.32e-06), .pd(4.32e-06), .nrs(0.160714), .nrd(0.160714), .m((1)*(1)), .par1((1)*(1)))
(* integer passed_mfactor = "m"; *)
 M8 (PO, net14, net37, GND);
ne3i #(.w(1.68e-06), .l(4e-07), .as(8.064e-13), .ad(8.064e-13), .ps(4.32e-06), .pd(4.32e-06), .nrs(0.160714), .nrd(0.160714), .m((1)*(1)), .par1((1)*(1)))
(* integer passed_mfactor = "m"; *)
 M10 (net37, PI, GND, GND);
ne3i #(.w(1.68e-06), .l(4e-07), .as(8.064e-13), .ad(4.536e-13), .ps(4.32e-06), .pd(2.22e-06), .nrs(0.160714), .nrd(0.160714), .m((1)*(2)), .par1((1)*(2)))
(* integer passed_mfactor = "m"; *)
 M13 (net19, net14, GND, GND);
ne3i #(.w(1.68e-06), .l(4e-07), .as(6.3e-13), .ad(4.536e-13), .ps(3.27e-06), .pd(2.22e-06), .nrs(0.160714), .nrd(0.160714), .m((1)*(4)), .par1((1)*(4)))
(* integer passed_mfactor = "m"; *)
 M4 (net16, net14, GND, GND);

endmodule
// Library - IO_CELLS_JIC3V, Cell - jio_bufc_pc, View - cmos_sch
// LAST TIME SAVED: Nov 16 02:00:21 2021
// NETLIST TIME: Feb 12 01:23:42 2024

`worklib IO_CELLS_JIC3V
`view cmos_sch

`timescale 1ns / 1ps
(* cds_ams_schematic *)

module jio_bufc_pc (Y, A, GNDR, VDDR);
output  Y;
input  A, GNDR, VDDR;
ne3i #(.w(2e-06), .l(4e-07), .as(9.6e-13), .ad(9.6e-13), .ps(4.96e-06), .pd(4.96e-06), .nrs(0.135), .nrd(0.135), .m((1)*(3)), .par1((1)*(3)))
(* integer passed_mfactor = "m"; *)
 M2 (Y, A, GNDR, GNDR);
pe3i #(.w(2.2e-06), .l(3.5e-07), .as(9.6e-13), .ad(9.6e-13), .ps(4.96e-06), .pd(4.96e-06), .nrs(0.135), .nrd(0.135), .m((1)*(6)), .par1((1)*(6)))
(* integer passed_mfactor = "m"; *)
 M1 (Y, A, VDDR, VDDR);

endmodule
// Library - IO_CELLS_JIC3V, Cell - jio_resp_pc, View - cmos_sch
// LAST TIME SAVED: Nov 16 11:13:59 2021
// NETLIST TIME: Feb 12 01:23:42 2024

`worklib IO_CELLS_JIC3V
`view cmos_sch

`timescale 1ns / 1ps
(* cds_ams_schematic *)

module jio_resp_pc (RH, GNDO, VDDO);
output  RH;
input  GNDO, VDDO;
rdp3 #(.l(3.3e-06), .w(4.4e-07), .m(1), .par1(1))
(* integer passed_mfactor = "m"; *)
 R0 (VDDO, RH, VDDO);

endmodule
// Library - IO_CELLS_JIC3V, Cell - jio_ne3is_pc, View - cmos_sch
// LAST TIME SAVED: Nov 16 11:09:51 2021
// NETLIST TIME: Feb 12 01:23:42 2024

`worklib IO_CELLS_JIC3V
`view cmos_sch

`timescale 1ns / 1ps
(* cds_ams_schematic *)

module jio_ne3is_pc (B, D, G, S);
inout  B, D, G, S;
dn3 #(.area(3.96e-12), .perimeter(6.6e-07), .dbv(0), .m(1), .par1(1), .xf_subext(0))
(* integer passed_mfactor = "m"; *)
 D3 (B, D);
rdn3 #(.l(1.32e-06), .w(1.2e-05), .m(1), .par1(1), .xf_subext(0))
(* integer passed_mfactor = "m"; *)
 R4 (D, net6, B);
ne3i #(.w(1.2e-05), .l(4e-07), .as(5.76e-12), .ad(5.76e-12), .ps(2.496e-05), .pd(2.496e-05), .nrs(0.0225), .nrd(0.0225), .m((1)*(1)), .par1((1)*(1)))
(* integer passed_mfactor = "m"; *)
 M0 (net6, G, S, B);

endmodule
// Library - IO_CELLS_JIC3V, Cell - jio_esd1_pc, View - cmos_sch
// LAST TIME SAVED: Nov 16 11:06:13 2021
// NETLIST TIME: Feb 12 01:23:42 2024

`worklib IO_CELLS_JIC3V
`view cmos_sch

`timescale 1ns / 1ps
(* cds_ams_schematic *)

module jio_esd1_pc (Y, A, GNDO, GNDR, PSUB, VDDO, VDDR);
output  Y;
input  A, GNDO, GNDR, PSUB, VDDO, VDDR;
wire rh;
wire ng;
jio_resp_pc I3 (.RH( rh ), .VDDO( VDDO ), .GNDO( GNDO ));
jio_pe3i_pc IP_1 (.S( VDDO ), .G( rh ), .B( VDDO ), .D( A ));
jio_pe3i_pc IP_2 (.S( VDDO ), .G( rh ), .B( VDDO ), .D( A ));
jio_pe3i_pc IP_3 (.S( VDDO ), .G( rh ), .B( VDDO ), .D( A ));
jio_pe3i_pc IP_4 (.S( VDDO ), .G( rh ), .B( VDDO ), .D( A ));
jio_pe3i_pc IP_5 (.S( VDDO ), .G( rh ), .B( VDDO ), .D( A ));
jio_pe3i_pc IP_6 (.S( VDDO ), .G( rh ), .B( VDDO ), .D( A ));
jio_pe3i_pc IP_7 (.S( VDDO ), .G( rh ), .B( VDDO ), .D( A ));
jio_pe3i_pc IP_8 (.S( VDDO ), .G( rh ), .B( VDDO ), .D( A ));
jio_pe3i_pc IP_9 (.S( VDDO ), .G( rh ), .B( VDDO ), .D( A ));
jio_pe3i_pc IP_10 (.S( VDDO ), .G( rh ), .B( VDDO ), .D( A ));
jio_pe3i_pc IP_11 (.S( VDDO ), .G( rh ), .B( VDDO ), .D( A ));
jio_pe3i_pc IP_12 (.S( VDDO ), .G( rh ), .B( VDDO ), .D( A ));
jio_pe3i_pc IP_13 (.S( VDDO ), .G( rh ), .B( VDDO ), .D( A ));
jio_pe3i_pc IP_14 (.S( VDDO ), .G( rh ), .B( VDDO ), .D( A ));
jio_pe3i_pc IP_15 (.S( VDDO ), .G( rh ), .B( VDDO ), .D( A ));
jio_pe3i_pc IP_16 (.S( VDDO ), .G( rh ), .B( VDDO ), .D( A ));
jio_pe3i_pc IP_17 (.S( VDDO ), .G( rh ), .B( VDDO ), .D( A ));
jio_pe3i_pc IP_18 (.S( VDDO ), .G( rh ), .B( VDDO ), .D( A ));
jio_pe3i_pc IP_19 (.S( VDDO ), .G( rh ), .B( VDDO ), .D( A ));
jio_pe3i_pc IP_20 (.S( VDDO ), .G( rh ), .B( VDDO ), .D( A ));
jio_pe3i_pc IP_21 (.S( VDDO ), .G( rh ), .B( VDDO ), .D( A ));
jio_pe3i_pc IP_22 (.S( VDDO ), .G( rh ), .B( VDDO ), .D( A ));
jio_pe3i_pc IP_23 (.S( VDDO ), .G( rh ), .B( VDDO ), .D( A ));
jio_pe3i_pc IP_24 (.S( VDDO ), .G( rh ), .B( VDDO ), .D( A ));
jio_ne3i_pc IN_1 (.D( A ), .B( GNDO ), .G( ng ), .S( GNDO ));
jio_ne3i_pc IN_2 (.D( A ), .B( GNDO ), .G( ng ), .S( GNDO ));
jio_ne3i_pc IN_3 (.D( A ), .B( GNDO ), .G( ng ), .S( GNDO ));
jio_ne3i_pc IN_4 (.D( A ), .B( GNDO ), .G( ng ), .S( GNDO ));
jio_ne3i_pc IN_5 (.D( A ), .B( GNDO ), .G( ng ), .S( GNDO ));
jio_ne3i_pc IN_6 (.D( A ), .B( GNDO ), .G( ng ), .S( GNDO ));
jio_ne3i_pc IN_7 (.D( A ), .B( GNDO ), .G( ng ), .S( GNDO ));
jio_ne3i_pc IN_8 (.D( A ), .B( GNDO ), .G( ng ), .S( GNDO ));
jio_ne3i_pc IN_9 (.D( A ), .B( GNDO ), .G( ng ), .S( GNDO ));
jio_ne3i_pc IN_10 (.D( A ), .B( GNDO ), .G( ng ), .S( GNDO ));
jio_ne3i_pc IN_11 (.D( A ), .B( GNDO ), .G( ng ), .S( GNDO ));
jio_ne3i_pc IN_12 (.D( A ), .B( GNDO ), .G( ng ), .S( GNDO ));
jio_ne3i_pc IN_13 (.D( A ), .B( GNDO ), .G( ng ), .S( GNDO ));
jio_ne3i_pc IN_14 (.D( A ), .B( GNDO ), .G( ng ), .S( GNDO ));
jio_ne3i_pc IN_15 (.D( A ), .B( GNDO ), .G( ng ), .S( GNDO ));
jio_ne3i_pc IN_16 (.D( A ), .B( GNDO ), .G( ng ), .S( GNDO ));
jio_ne3i_pc IN_17 (.D( A ), .B( GNDO ), .G( ng ), .S( GNDO ));
jio_ne3i_pc IN_18 (.D( A ), .B( GNDO ), .G( ng ), .S( GNDO ));
jio_ne3i_pc IN_19 (.D( A ), .B( GNDO ), .G( ng ), .S( GNDO ));
jio_ne3i_pc IN_20 (.D( A ), .B( GNDO ), .G( ng ), .S( GNDO ));
jio_ne3i_pc IN_21 (.D( A ), .B( GNDO ), .G( ng ), .S( GNDO ));
jio_ne3i_pc IN_22 (.D( A ), .B( GNDO ), .G( ng ), .S( GNDO ));
jio_ne3i_pc IN_23 (.D( A ), .B( GNDO ), .G( ng ), .S( GNDO ));
jio_ne3i_pc IN_24 (.D( A ), .B( GNDO ), .G( ng ), .S( GNDO ));
jio_ne3is_pc INS_1 (.D( Y ), .B( GNDO ), .G( GNDO ), .S( GNDO ));
jio_ne3is_pc INS_2 (.D( Y ), .B( GNDO ), .G( GNDO ), .S( GNDO ));
pe3i #(.w(1.2e-05), .l(3.5e-07), .as(5.76e-12), .ad(3.24e-12), .ps(2.496e-05), .pd(1.254e-05), .nrs(0.0225), .nrd(0.0225), .m((1)*(2)), .par1((1)*(2)))
(* integer passed_mfactor = "m"; *)
 M3 (Y, VDDO, VDDO, VDDO);
rpp1 #(.l(4.5e-06), .w(2.5e-06), .m(1), .par1(1))
(* integer passed_mfactor = "m"; *)
 R1 (A, Y);
ne3i #(.w(1.2e-06), .l(4e-07), .as(5.76e-13), .ad(5.76e-13), .ps(3.36e-06), .pd(3.36e-06), .nrs(0.225), .nrd(0.225), .m((1)*(1)), .par1((1)*(1)))
(* integer passed_mfactor = "m"; *)
 M2 (ng, rh, GNDO, GNDO);

endmodule
// Library - IO_CELLS_JIC3V, Cell - ICPC, View - cmos_sch
// LAST TIME SAVED: Nov 16 02:00:25 2021
// NETLIST TIME: Feb 12 01:23:42 2024

`worklib IO_CELLS_JIC3V
`view cmos_sch

`timescale 1ns / 1ps
(* cds_ams_schematic *)

module ICPC (PO, Y, GNDI, GNDOI, GNDRI, PAD, PI, PSUB, VDD3I, VDDOI, VDDRI);
output  PO, Y;
input  GNDI, GNDOI, GNDRI, PAD, PI, PSUB, VDD3I, VDDOI, VDDRI;
wire net12;
wire net13;
jio_ipdio_pc I5 (.PSUB( PSUB ), .DNWR( VDDRI ), .PWIR( GNDRI ));
jio_opdio_pc I6 (.VDN( VDDOI ), .PSUB( PSUB ), .NW( VDDOI ), .DNLW( VDD3I ), .DNW( VDDOI ), .PWI( GNDOI ), .LPWI( GNDI ));
jio_ndtr_pc I4 (.YN( net12 ), .PI( PI ), .PO( PO ), .VDD( VDD3I ), .Y( Y ), .VDDR( VDDRI ), .GNDR( GNDRI ), .GND( GNDI ));
jio_bufc_pc I3 (.A( net13 ), .Y( net12 ), .VDDR( VDDRI ), .GNDR( GNDRI ));
jio_esd1_pc I1 (.Y( net13 ), .A( PAD ), .GNDO( GNDOI ), .VDDR( VDDRI ), .GNDR( GNDRI ), .VDDO( VDDOI ), .PSUB( PSUB ));

endmodule
// Library - IO_CELLS_JIC3V, Cell - jio_tp4_pc, View - cmos_sch
// LAST TIME SAVED: Nov 16 02:00:07 2021
// NETLIST TIME: Feb 12 01:23:42 2024

`worklib IO_CELLS_JIC3V
`view cmos_sch

`timescale 1ns / 1ps
(* cds_ams_schematic *)

module jio_tp4_pc (NG1, NG2, PG1, PG2, GNDO, NG, NW, PG, PW, VDDO);
output  NG1, NG2, PG1, PG2;
input  GNDO, NG, NW, PG, PW, VDDO;
ne3i #(.w(6.1e-06), .l(4e-07), .as(9.6e-13), .ad(9.6e-13), .ps(4.96e-06), .pd(4.96e-06), .nrs(0.135), .nrd(0.135), .m((1)*(1)), .par1((1)*(1)))
(* integer passed_mfactor = "m"; *)
 M11 (PG1, PG, GNDO, PW);
ne3i #(.w(3.7e-06), .l(4e-07), .as(9.6e-13), .ad(9.6e-13), .ps(4.96e-06), .pd(4.96e-06), .nrs(0.135), .nrd(0.135), .m((1)*(1)), .par1((1)*(1)))
(* integer passed_mfactor = "m"; *)
 M13 (PG2, PG, net26, PW);
ne3i #(.w(5.5e-06), .l(4e-07), .as(9.6e-13), .ad(9.6e-13), .ps(4.96e-06), .pd(4.96e-06), .nrs(0.135), .nrd(0.135), .m((1)*(2)), .par1((1)*(2)))
(* integer passed_mfactor = "m"; *)
 M21 (NG1, NG, GNDO, PW);
ne3i #(.w(3.7e-06), .l(4e-07), .as(9.6e-13), .ad(9.6e-13), .ps(4.96e-06), .pd(4.96e-06), .nrs(0.135), .nrd(0.135), .m((1)*(1)), .par1((1)*(1)))
(* integer passed_mfactor = "m"; *)
 M14 (net26, PG, GNDO, PW);
ne3i #(.w(8e-06), .l(4e-07), .as(9.6e-13), .ad(9.6e-13), .ps(4.96e-06), .pd(4.96e-06), .nrs(0.135), .nrd(0.135), .m((1)*(2)), .par1((1)*(2)))
(* integer passed_mfactor = "m"; *)
 M24 (NG2, NG, GNDO, PW);
pe3i #(.w(1e-05), .l(3.5e-07), .as(4.8e-12), .ad(2.7e-12), .ps(2.096e-05), .pd(1.054e-05), .nrs(0.027), .nrd(0.027), .m((1)*(2)), .par1((1)*(2)))
(* integer passed_mfactor = "m"; *)
 M10 (PG1, PG, VDDO, NW);
pe3i #(.w(4.9e-06), .l(3.5e-07), .as(9.6e-13), .ad(9.6e-13), .ps(4.96e-06), .pd(4.96e-06), .nrs(0.135), .nrd(0.135), .m((1)*(1)), .par1((1)*(1)))
(* integer passed_mfactor = "m"; *)
 M20 (NG1, NG, VDDO, NW);
pe3i #(.w(6.7e-06), .l(4e-07), .as(9.6e-13), .ad(9.6e-13), .ps(4.96e-06), .pd(4.96e-06), .nrs(0.135), .nrd(0.135), .m((1)*(1)), .par1((1)*(1)))
(* integer passed_mfactor = "m"; *)
 M23 (NG2, NG, net25, NW);
pe3i #(.w(6.7e-06), .l(4e-07), .as(9.6e-13), .ad(9.6e-13), .ps(4.96e-06), .pd(4.96e-06), .nrs(0.135), .nrd(0.135), .m((1)*(1)), .par1((1)*(1)))
(* integer passed_mfactor = "m"; *)
 M22 (net25, NG, VDDO, NW);
pe3i #(.w(1e-05), .l(3.5e-07), .as(4.8e-12), .ad(2.7e-12), .ps(2.096e-05), .pd(1.054e-05), .nrs(0.027), .nrd(0.027), .m((1)*(2)), .par1((1)*(2)))
(* integer passed_mfactor = "m"; *)
 M12 (PG2, PG, VDDO, NW);

endmodule
// Library - IO_CELLS_JIC3V, Cell - jio_tsctrl_pc, View - cmos_sch
// LAST TIME SAVED: Nov 16 02:00:00 2021
// NETLIST TIME: Feb 12 01:23:42 2024

`worklib IO_CELLS_JIC3V
`view cmos_sch

`timescale 1ns / 1ps
(* cds_ams_schematic *)

module jio_tsctrl_pc (NG, PG, A, EN, GND, GNDO, VDD, VDDO);
output  NG, PG;
input  A, EN, GND, GNDO, VDD, VDDO;
pe3i #(.w(5.2e-06), .l(3.5e-07), .as(2.496e-12), .ad(1.404e-12), .ps(1.136e-05), .pd(5.74e-06), .nrs(0.0519231), .nrd(0.0519231), .m((1)*(2)), .par1((1)*(2)))
(* integer passed_mfactor = "m"; *)
 M127 (NG, NGB, VDDO, VDDO);
pe3i #(.w(5.2e-06), .l(3.5e-07), .as(2.496e-12), .ad(1.404e-12), .ps(1.136e-05), .pd(5.74e-06), .nrs(0.0519231), .nrd(0.0519231), .m((1)*(2)), .par1((1)*(2)))
(* integer passed_mfactor = "m"; *)
 M117 (PG, PGB, VDDO, VDDO);
pe3i #(.w(2.16e-06), .l(3.5e-07), .as(1.0368e-12), .ad(1.0368e-12), .ps(5.28e-06), .pd(5.28e-06), .nrs(0.125), .nrd(0.125), .m((1)*(1)), .par1((1)*(1)))
(* integer passed_mfactor = "m"; *)
 M01 (ENB, EN, VDD, VDD);
pe3i #(.w(2.16e-06), .l(3.5e-07), .as(1.0368e-12), .ad(1.0368e-12), .ps(5.28e-06), .pd(5.28e-06), .nrs(0.125), .nrd(0.125), .m((1)*(1)), .par1((1)*(1)))
(* integer passed_mfactor = "m"; *)
 M22 (NGB, EN, net49, VDD);
pe3i #(.w(2.16e-06), .l(3.5e-07), .as(1.0368e-12), .ad(1.0368e-12), .ps(5.28e-06), .pd(5.28e-06), .nrs(0.125), .nrd(0.125), .m((1)*(1)), .par1((1)*(1)))
(* integer passed_mfactor = "m"; *)
 M12 (PGB, ENB, VDD, VDD);
pe3i #(.w(2.16e-06), .l(3.5e-07), .as(1.0368e-12), .ad(1.0368e-12), .ps(5.28e-06), .pd(5.28e-06), .nrs(0.125), .nrd(0.125), .m((1)*(1)), .par1((1)*(1)))
(* integer passed_mfactor = "m"; *)
 M21 (net49, A, VDD, VDD);
pe3i #(.w(2.16e-06), .l(3.5e-07), .as(1.0368e-12), .ad(1.0368e-12), .ps(5.28e-06), .pd(5.28e-06), .nrs(0.125), .nrd(0.125), .m((1)*(1)), .par1((1)*(1)))
(* integer passed_mfactor = "m"; *)
 M11 (PGB, A, VDD, VDD);
ne3i #(.w(5.2e-06), .l(4e-07), .as(2.496e-12), .ad(2.496e-12), .ps(1.136e-05), .pd(1.136e-05), .nrs(0.0519231), .nrd(0.0519231), .m((1)*(1)), .par1((1)*(1)))
(* integer passed_mfactor = "m"; *)
 M128 (NG, NGB, GNDO, GNDO);
ne3i #(.w(5.2e-06), .l(4e-07), .as(2.496e-12), .ad(2.496e-12), .ps(1.136e-05), .pd(1.136e-05), .nrs(0.0519231), .nrd(0.0519231), .m((1)*(1)), .par1((1)*(1)))
(* integer passed_mfactor = "m"; *)
 M118 (PG, PGB, GNDO, GNDO);
ne3i #(.w(1.1e-06), .l(4e-07), .as(5.28e-13), .ad(5.28e-13), .ps(3.16e-06), .pd(3.16e-06), .nrs(0.245455), .nrd(0.245455), .m((1)*(1)), .par1((1)*(1)))
(* integer passed_mfactor = "m"; *)
 M02 (ENB, EN, GND, GND);
ne3i #(.w(1.1e-06), .l(4e-07), .as(5.28e-13), .ad(2.97e-13), .ps(3.16e-06), .pd(1.64e-06), .nrs(0.245455), .nrd(0.245455), .m((1)*(2)), .par1((1)*(2)))
(* integer passed_mfactor = "m"; *)
 M24 (NGB, A, GND, GND);
ne3i #(.w(1.1e-06), .l(4e-07), .as(5.28e-13), .ad(2.97e-13), .ps(3.16e-06), .pd(1.64e-06), .nrs(0.245455), .nrd(0.245455), .m((1)*(2)), .par1((1)*(2)))
(* integer passed_mfactor = "m"; *)
 M15 (net50, A, GND, GND);
ne3i #(.w(1.1e-06), .l(4e-07), .as(5.28e-13), .ad(2.97e-13), .ps(3.16e-06), .pd(1.64e-06), .nrs(0.245455), .nrd(0.245455), .m((1)*(2)), .par1((1)*(2)))
(* integer passed_mfactor = "m"; *)
 M25 (NGB, EN, GND, GND);
ne3i #(.w(1.1e-06), .l(4e-07), .as(5.28e-13), .ad(2.97e-13), .ps(3.16e-06), .pd(1.64e-06), .nrs(0.245455), .nrd(0.245455), .m((1)*(2)), .par1((1)*(2)))
(* integer passed_mfactor = "m"; *)
 M14 (PGB, ENB, net50, GND);

endmodule
// Library - IO_CELLS_JIC3V, Cell - jio_ts4_pc, View - cmos_sch
// LAST TIME SAVED: Nov 16 02:00:01 2021
// NETLIST TIME: Feb 12 01:23:42 2024

`worklib IO_CELLS_JIC3V
`view cmos_sch

`timescale 1ns / 1ps
(* cds_ams_schematic *)

module jio_ts4_pc (PAD, A, EN, GND, GNDO, PSUB, VDD, VDDO, VDN);
output  PAD;
input  A, EN, GND, GNDO, PSUB, VDD, VDDO, VDN;
wire pg1;
wire pg2;
wire rh;
wire ng3;
wire ng2;
wire ng1;
wire pg;
wire ng;
jio_pe3i_pc IP1_1 (.D( PAD ), .B( VDDO ), .G( pg1 ), .S( VDDO ));
jio_pe3i_pc IP1_2 (.D( PAD ), .B( VDDO ), .G( pg1 ), .S( VDDO ));
jio_pe3i_pc IP1_3 (.D( PAD ), .B( VDDO ), .G( pg1 ), .S( VDDO ));
jio_pe3i_pc IP2_1 (.D( PAD ), .B( VDDO ), .G( pg2 ), .S( VDDO ));
jio_pe3i_pc IP2_2 (.D( PAD ), .B( VDDO ), .G( pg2 ), .S( VDDO ));
jio_pe3i_pc IP2_3 (.D( PAD ), .B( VDDO ), .G( pg2 ), .S( VDDO ));
jio_pe3i_pc IP3_1 (.S( VDDO ), .G( rh ), .B( VDDO ), .D( PAD ));
jio_pe3i_pc IP3_2 (.S( VDDO ), .G( rh ), .B( VDDO ), .D( PAD ));
jio_pe3i_pc IP3_3 (.S( VDDO ), .G( rh ), .B( VDDO ), .D( PAD ));
jio_pe3i_pc IP3_4 (.S( VDDO ), .G( rh ), .B( VDDO ), .D( PAD ));
jio_pe3i_pc IP3_5 (.S( VDDO ), .G( rh ), .B( VDDO ), .D( PAD ));
jio_pe3i_pc IP3_6 (.S( VDDO ), .G( rh ), .B( VDDO ), .D( PAD ));
jio_pe3i_pc IP3_7 (.S( VDDO ), .G( rh ), .B( VDDO ), .D( PAD ));
jio_pe3i_pc IP3_8 (.S( VDDO ), .G( rh ), .B( VDDO ), .D( PAD ));
jio_pe3i_pc IP3_9 (.S( VDDO ), .G( rh ), .B( VDDO ), .D( PAD ));
jio_pe3i_pc IP3_10 (.S( VDDO ), .G( rh ), .B( VDDO ), .D( PAD ));
jio_pe3i_pc IP3_11 (.S( VDDO ), .G( rh ), .B( VDDO ), .D( PAD ));
jio_pe3i_pc IP3_12 (.S( VDDO ), .G( rh ), .B( VDDO ), .D( PAD ));
jio_pe3i_pc IP3_13 (.S( VDDO ), .G( rh ), .B( VDDO ), .D( PAD ));
jio_pe3i_pc IP3_14 (.S( VDDO ), .G( rh ), .B( VDDO ), .D( PAD ));
jio_pe3i_pc IP3_15 (.S( VDDO ), .G( rh ), .B( VDDO ), .D( PAD ));
jio_pe3i_pc IP3_16 (.S( VDDO ), .G( rh ), .B( VDDO ), .D( PAD ));
jio_pe3i_pc IP3_17 (.S( VDDO ), .G( rh ), .B( VDDO ), .D( PAD ));
jio_pe3i_pc IP3_18 (.S( VDDO ), .G( rh ), .B( VDDO ), .D( PAD ));
jio_resp_pc I5 (.RH( rh ), .VDDO( VDDO ), .GNDO( GNDO ));
jio_opdio_pc I3 (.VDN( VDN ), .PSUB( PSUB ), .NW( VDDO ), .DNLW( VDD ), .DNW( VDDO ), .PWI( GNDO ), .LPWI( GND ));
jio_ne3i_pc IN3_1 (.D( PAD ), .B( GNDO ), .G( ng3 ), .S( GNDO ));
jio_ne3i_pc IN3_2 (.D( PAD ), .B( GNDO ), .G( ng3 ), .S( GNDO ));
jio_ne3i_pc IN3_3 (.D( PAD ), .B( GNDO ), .G( ng3 ), .S( GNDO ));
jio_ne3i_pc IN3_4 (.D( PAD ), .B( GNDO ), .G( ng3 ), .S( GNDO ));
jio_ne3i_pc IN3_5 (.D( PAD ), .B( GNDO ), .G( ng3 ), .S( GNDO ));
jio_ne3i_pc IN3_6 (.D( PAD ), .B( GNDO ), .G( ng3 ), .S( GNDO ));
jio_ne3i_pc IN3_7 (.D( PAD ), .B( GNDO ), .G( ng3 ), .S( GNDO ));
jio_ne3i_pc IN3_8 (.D( PAD ), .B( GNDO ), .G( ng3 ), .S( GNDO ));
jio_ne3i_pc IN3_9 (.D( PAD ), .B( GNDO ), .G( ng3 ), .S( GNDO ));
jio_ne3i_pc IN3_10 (.D( PAD ), .B( GNDO ), .G( ng3 ), .S( GNDO ));
jio_ne3i_pc IN3_11 (.D( PAD ), .B( GNDO ), .G( ng3 ), .S( GNDO ));
jio_ne3i_pc IN3_12 (.D( PAD ), .B( GNDO ), .G( ng3 ), .S( GNDO ));
jio_ne3i_pc IN3_13 (.D( PAD ), .B( GNDO ), .G( ng3 ), .S( GNDO ));
jio_ne3i_pc IN3_14 (.D( PAD ), .B( GNDO ), .G( ng3 ), .S( GNDO ));
jio_ne3i_pc IN3_15 (.D( PAD ), .B( GNDO ), .G( ng3 ), .S( GNDO ));
jio_ne3i_pc IN3_16 (.D( PAD ), .B( GNDO ), .G( ng3 ), .S( GNDO ));
jio_ne3i_pc IN3_17 (.D( PAD ), .B( GNDO ), .G( ng3 ), .S( GNDO ));
jio_ne3i_pc IN3_18 (.D( PAD ), .B( GNDO ), .G( ng3 ), .S( GNDO ));
jio_ne3i_pc IN3_19 (.D( PAD ), .B( GNDO ), .G( ng3 ), .S( GNDO ));
jio_ne3i_pc IN3_20 (.D( PAD ), .B( GNDO ), .G( ng3 ), .S( GNDO ));
jio_ne3i_pc IN3_21 (.D( PAD ), .B( GNDO ), .G( ng3 ), .S( GNDO ));
jio_ne3i_pc IN2_1 (.S( GNDO ), .G( ng2 ), .B( GNDO ), .D( PAD ));
jio_ne3i_pc IN2_2 (.S( GNDO ), .G( ng2 ), .B( GNDO ), .D( PAD ));
jio_ne3i_pc IN1 (.S( GNDO ), .G( ng1 ), .B( GNDO ), .D( PAD ));
jio_tp4_pc I2 (.NW( VDDO ), .NG1( ng1 ), .NG( ng ), .VDDO( VDDO ), .PG( pg ), .PG1( pg1 ), .PG2( pg2 ), .PW( GNDO ), .GNDO( GNDO ), .NG2( ng2 ));
jio_tsctrl_pc I1 (.VDDO( VDDO ), .PG( pg ), .NG( ng ), .VDD( VDD ), .GNDO( GNDO ), .EN( EN ), .GND( GND ), .A( A ));
ne3i #(.w(1.2e-06), .l(4e-07), .as(9.6e-13), .ad(9.6e-13), .ps(4.96e-06), .pd(4.96e-06), .nrs(0.135), .nrd(0.135), .m((1)*(1)), .par1((1)*(1)))
(* integer passed_mfactor = "m"; *)
 M0 (ng3, rh, GNDO, GNDO);

endmodule
// Library - IO_CELLS_JIC3V, Cell - BT4PC, View - cmos_sch
// LAST TIME SAVED: Nov 16 02:00:29 2021
// NETLIST TIME: Feb 12 01:23:42 2024

`worklib IO_CELLS_JIC3V
`view cmos_sch

`timescale 1ns / 1ps
(* cds_ams_schematic *)

module BT4PC (PAD, A, EN, GNDI, GNDOI, GNDRI, PSUB, VDD3I, VDDOI, VDDRI);
output  PAD;
input  A, EN, GNDI, GNDOI, GNDRI, PSUB, VDD3I, VDDOI, VDDRI;
jio_ts4_pc I0 (.A( A ), .PAD( PAD ), .EN( EN ), .VDDO( VDDOI ), .VDD( VDD3I ), .GNDO( GNDOI ), .PSUB( PSUB ), .VDN( VDDOI ), .GND( GNDI ));
jio_ipdio_pc I5 (.PSUB( PSUB ), .DNWR( VDDRI ), .PWIR( GNDRI ));

endmodule
// Library - IO_CELLS_JIC3V, Cell - PWRCUTDCPC, View - cmos_sch
// LAST TIME SAVED: Nov 16 02:00:24 2021
// NETLIST TIME: Feb 12 01:23:42 2024

`worklib IO_CELLS_JIC3V
`view cmos_sch

`timescale 1ns / 1ps
(* cds_ams_schematic *)

module PWRCUTDCPC (GNDI1, GNDI2, GNDOI1, GNDOI2, GNDRI1, GNDRI2, PSUB, VDD3I1, VDD3I2, VDDOI1, VDDOI2, VDDRI1, VDDRI2);
input  GNDI1, GNDI2, GNDOI1, GNDOI2, GNDRI1, GNDRI2, PSUB, VDD3I1, VDD3I2, VDDOI1, VDDOI2, VDDRI1, VDDRI2;
dp3 #(.area(5.91506e-11), .perimeter(6.486e-05), .dbv(0), .m(1), .par1(1))
(* integer passed_mfactor = "m"; *)
 D4_1 (GNDOI1, GNDOI2);
dp3 #(.area(5.91506e-11), .perimeter(6.486e-05), .dbv(0), .m(1), .par1(1))
(* integer passed_mfactor = "m"; *)
 D4_2 (GNDOI1, GNDOI2);
dp3 #(.area(5.91506e-11), .perimeter(6.486e-05), .dbv(0), .m(1), .par1(1))
(* integer passed_mfactor = "m"; *)
 D4_3 (GNDOI1, GNDOI2);
dp3 #(.area(5.91506e-11), .perimeter(6.486e-05), .dbv(0), .m(1), .par1(1))
(* integer passed_mfactor = "m"; *)
 D4_4 (GNDOI1, GNDOI2);
dp3 #(.area(5.91506e-11), .perimeter(6.486e-05), .dbv(0), .m(1), .par1(1))
(* integer passed_mfactor = "m"; *)
 D4_5 (GNDOI1, GNDOI2);
dp3 #(.area(5.91506e-11), .perimeter(6.486e-05), .dbv(0), .m(1), .par1(1))
(* integer passed_mfactor = "m"; *)
 D4_6 (GNDOI1, GNDOI2);
dp3 #(.area(5.91506e-11), .perimeter(6.486e-05), .dbv(0), .m(1), .par1(1))
(* integer passed_mfactor = "m"; *)
 D4_7 (GNDOI1, GNDOI2);
dp3 #(.area(5.91506e-11), .perimeter(6.486e-05), .dbv(0), .m(1), .par1(1))
(* integer passed_mfactor = "m"; *)
 D4_8 (GNDOI1, GNDOI2);
dp3 #(.area(5.91506e-11), .perimeter(6.486e-05), .dbv(0), .m(1), .par1(1))
(* integer passed_mfactor = "m"; *)
 D4_9 (GNDOI1, GNDOI2);
dp3 #(.area(5.91506e-11), .perimeter(6.486e-05), .dbv(0), .m(1), .par1(1))
(* integer passed_mfactor = "m"; *)
 D4_10 (GNDOI1, GNDOI2);
dp3 #(.area(5.91506e-11), .perimeter(6.486e-05), .dbv(0), .m(1), .par1(1))
(* integer passed_mfactor = "m"; *)
 D4_11 (GNDOI1, GNDOI2);
dp3 #(.area(5.91506e-11), .perimeter(6.486e-05), .dbv(0), .m(1), .par1(1))
(* integer passed_mfactor = "m"; *)
 D4_12 (GNDOI1, GNDOI2);
dp3 #(.area(5.91506e-11), .perimeter(6.486e-05), .dbv(0), .m(1), .par1(1))
(* integer passed_mfactor = "m"; *)
 D4_13 (GNDOI1, GNDOI2);
dp3 #(.area(5.91506e-11), .perimeter(6.486e-05), .dbv(0), .m(1), .par1(1))
(* integer passed_mfactor = "m"; *)
 D4_14 (GNDOI1, GNDOI2);
dp3 #(.area(5.91506e-11), .perimeter(6.486e-05), .dbv(0), .m(1), .par1(1))
(* integer passed_mfactor = "m"; *)
 D1_1 (GNDOI2, GNDOI1);
dp3 #(.area(5.91506e-11), .perimeter(6.486e-05), .dbv(0), .m(1), .par1(1))
(* integer passed_mfactor = "m"; *)
 D1_2 (GNDOI2, GNDOI1);
dp3 #(.area(5.91506e-11), .perimeter(6.486e-05), .dbv(0), .m(1), .par1(1))
(* integer passed_mfactor = "m"; *)
 D1_3 (GNDOI2, GNDOI1);
dp3 #(.area(5.91506e-11), .perimeter(6.486e-05), .dbv(0), .m(1), .par1(1))
(* integer passed_mfactor = "m"; *)
 D1_4 (GNDOI2, GNDOI1);
dp3 #(.area(5.91506e-11), .perimeter(6.486e-05), .dbv(0), .m(1), .par1(1))
(* integer passed_mfactor = "m"; *)
 D1_5 (GNDOI2, GNDOI1);
dp3 #(.area(5.91506e-11), .perimeter(6.486e-05), .dbv(0), .m(1), .par1(1))
(* integer passed_mfactor = "m"; *)
 D1_6 (GNDOI2, GNDOI1);
dp3 #(.area(5.91506e-11), .perimeter(6.486e-05), .dbv(0), .m(1), .par1(1))
(* integer passed_mfactor = "m"; *)
 D1_7 (GNDOI2, GNDOI1);
dp3 #(.area(5.91506e-11), .perimeter(6.486e-05), .dbv(0), .m(1), .par1(1))
(* integer passed_mfactor = "m"; *)
 D1_8 (GNDOI2, GNDOI1);
dp3 #(.area(5.91506e-11), .perimeter(6.486e-05), .dbv(0), .m(1), .par1(1))
(* integer passed_mfactor = "m"; *)
 D1_9 (GNDOI2, GNDOI1);
dp3 #(.area(5.91506e-11), .perimeter(6.486e-05), .dbv(0), .m(1), .par1(1))
(* integer passed_mfactor = "m"; *)
 D1_10 (GNDOI2, GNDOI1);
dp3 #(.area(5.91506e-11), .perimeter(6.486e-05), .dbv(0), .m(1), .par1(1))
(* integer passed_mfactor = "m"; *)
 D1_11 (GNDOI2, GNDOI1);
dp3 #(.area(5.91506e-11), .perimeter(6.486e-05), .dbv(0), .m(1), .par1(1))
(* integer passed_mfactor = "m"; *)
 D1_12 (GNDOI2, GNDOI1);
dp3 #(.area(5.91506e-11), .perimeter(6.486e-05), .dbv(0), .m(1), .par1(1))
(* integer passed_mfactor = "m"; *)
 D1_13 (GNDOI2, GNDOI1);
dp3 #(.area(5.91506e-11), .perimeter(6.486e-05), .dbv(0), .m(1), .par1(1))
(* integer passed_mfactor = "m"; *)
 D1_14 (GNDOI2, GNDOI1);
dp3 #(.area(5.91506e-11), .perimeter(6.486e-05), .dbv(0), .m(1), .par1(1))
(* integer passed_mfactor = "m"; *)
 D1_15 (GNDOI2, GNDOI1);

endmodule
// Library - IO_CELLS_JIC3V, Cell - CORNERESDPC, View - cmos_sch
// LAST TIME SAVED: Nov 16 10:57:47 2021
// NETLIST TIME: Feb 12 01:23:42 2024

`worklib IO_CELLS_JIC3V
`view cmos_sch

`timescale 1ns / 1ps
(* cds_ams_schematic *)

module CORNERESDPC (GNDI, GNDOI, GNDRI, PSUB, VDD3I, VDDOI, VDDRI);
input  GNDI, GNDOI, GNDRI, PSUB, VDD3I, VDDOI, VDDRI;
wire ng2;
wire ng1;
jio_ne3i_pc IN2_1 (.D( VDDOI ), .B( GNDOI ), .G( ng2 ), .S( GNDOI ));
jio_ne3i_pc IN2_2 (.D( VDDOI ), .B( GNDOI ), .G( ng2 ), .S( GNDOI ));
jio_ne3i_pc IN2_3 (.D( VDDOI ), .B( GNDOI ), .G( ng2 ), .S( GNDOI ));
jio_ne3i_pc IN2_4 (.D( VDDOI ), .B( GNDOI ), .G( ng2 ), .S( GNDOI ));
jio_ne3i_pc IN2_5 (.D( VDDOI ), .B( GNDOI ), .G( ng2 ), .S( GNDOI ));
jio_ne3i_pc IN2_6 (.D( VDDOI ), .B( GNDOI ), .G( ng2 ), .S( GNDOI ));
jio_ne3i_pc IN2_7 (.D( VDDOI ), .B( GNDOI ), .G( ng2 ), .S( GNDOI ));
jio_ne3i_pc IN2_8 (.D( VDDOI ), .B( GNDOI ), .G( ng2 ), .S( GNDOI ));
jio_ne3i_pc IN2_9 (.D( VDDOI ), .B( GNDOI ), .G( ng2 ), .S( GNDOI ));
jio_ne3i_pc IN2_10 (.D( VDDOI ), .B( GNDOI ), .G( ng2 ), .S( GNDOI ));
jio_ne3i_pc IN2_11 (.D( VDDOI ), .B( GNDOI ), .G( ng2 ), .S( GNDOI ));
jio_ne3i_pc IN2_12 (.D( VDDOI ), .B( GNDOI ), .G( ng2 ), .S( GNDOI ));
jio_ne3i_pc IN2_13 (.D( VDDOI ), .B( GNDOI ), .G( ng2 ), .S( GNDOI ));
jio_ne3i_pc IN2_14 (.D( VDDOI ), .B( GNDOI ), .G( ng2 ), .S( GNDOI ));
jio_ne3i_pc IN2_15 (.D( VDDOI ), .B( GNDOI ), .G( ng2 ), .S( GNDOI ));
jio_ne3i_pc IN2_16 (.D( VDDOI ), .B( GNDOI ), .G( ng2 ), .S( GNDOI ));
jio_ne3i_pc IN2_17 (.D( VDDOI ), .B( GNDOI ), .G( ng2 ), .S( GNDOI ));
jio_ne3i_pc IN2_18 (.D( VDDOI ), .B( GNDOI ), .G( ng2 ), .S( GNDOI ));
jio_ne3i_pc IN2_19 (.D( VDDOI ), .B( GNDOI ), .G( ng2 ), .S( GNDOI ));
jio_ne3i_pc IN2_20 (.D( VDDOI ), .B( GNDOI ), .G( ng2 ), .S( GNDOI ));
jio_ne3i_pc IN2_21 (.D( VDDOI ), .B( GNDOI ), .G( ng2 ), .S( GNDOI ));
jio_ne3i_pc IN2_22 (.D( VDDOI ), .B( GNDOI ), .G( ng2 ), .S( GNDOI ));
jio_ne3i_pc IN2_23 (.D( VDDOI ), .B( GNDOI ), .G( ng2 ), .S( GNDOI ));
jio_ne3i_pc IN2_24 (.D( VDDOI ), .B( GNDOI ), .G( ng2 ), .S( GNDOI ));
jio_ne3i_pc IN1_1 (.D( VDDOI ), .B( GNDOI ), .G( ng1 ), .S( GNDOI ));
jio_ne3i_pc IN1_2 (.D( VDDOI ), .B( GNDOI ), .G( ng1 ), .S( GNDOI ));
jio_ne3i_pc IN1_3 (.D( VDDOI ), .B( GNDOI ), .G( ng1 ), .S( GNDOI ));
jio_ne3i_pc IN1_4 (.D( VDDOI ), .B( GNDOI ), .G( ng1 ), .S( GNDOI ));
jio_ne3i_pc IN1_5 (.D( VDDOI ), .B( GNDOI ), .G( ng1 ), .S( GNDOI ));
jio_ne3i_pc IN1_6 (.D( VDDOI ), .B( GNDOI ), .G( ng1 ), .S( GNDOI ));
jio_ne3i_pc IN1_7 (.D( VDDOI ), .B( GNDOI ), .G( ng1 ), .S( GNDOI ));
jio_ne3i_pc IN1_8 (.D( VDDOI ), .B( GNDOI ), .G( ng1 ), .S( GNDOI ));
jio_ne3i_pc IN1_9 (.D( VDDOI ), .B( GNDOI ), .G( ng1 ), .S( GNDOI ));
jio_ne3i_pc IN1_10 (.D( VDDOI ), .B( GNDOI ), .G( ng1 ), .S( GNDOI ));
jio_ne3i_pc IN1_11 (.D( VDDOI ), .B( GNDOI ), .G( ng1 ), .S( GNDOI ));
jio_ne3i_pc IN1_12 (.D( VDDOI ), .B( GNDOI ), .G( ng1 ), .S( GNDOI ));
jio_ne3i_pc IN1_13 (.D( VDDOI ), .B( GNDOI ), .G( ng1 ), .S( GNDOI ));
jio_ne3i_pc IN1_14 (.D( VDDOI ), .B( GNDOI ), .G( ng1 ), .S( GNDOI ));
jio_ne3i_pc IN1_15 (.D( VDDOI ), .B( GNDOI ), .G( ng1 ), .S( GNDOI ));
jio_ne3i_pc IN1_16 (.D( VDDOI ), .B( GNDOI ), .G( ng1 ), .S( GNDOI ));
jio_ne3i_pc IN1_17 (.D( VDDOI ), .B( GNDOI ), .G( ng1 ), .S( GNDOI ));
jio_ne3i_pc IN1_18 (.D( VDDOI ), .B( GNDOI ), .G( ng1 ), .S( GNDOI ));
jio_ne3i_pc IN1_19 (.D( VDDOI ), .B( GNDOI ), .G( ng1 ), .S( GNDOI ));
jio_ne3i_pc IN1_20 (.D( VDDOI ), .B( GNDOI ), .G( ng1 ), .S( GNDOI ));
jio_ne3i_pc IN1_21 (.D( VDDOI ), .B( GNDOI ), .G( ng1 ), .S( GNDOI ));
jio_ne3i_pc IN1_22 (.D( VDDOI ), .B( GNDOI ), .G( ng1 ), .S( GNDOI ));
jio_ne3i_pc IN1_23 (.D( VDDOI ), .B( GNDOI ), .G( ng1 ), .S( GNDOI ));
jio_ne3i_pc IN1_24 (.D( VDDOI ), .B( GNDOI ), .G( ng1 ), .S( GNDOI ));
jio_andio_pc I1_1 (.PWI( GNDOI ), .DNW( VDDOI ), .PSUB( PSUB ));
jio_andio_pc I1_2 (.PWI( GNDOI ), .DNW( VDDOI ), .PSUB( PSUB ));
rdp3 #(.l(3.3e-06), .w(4.4e-07), .m(1), .par1(1))
(* integer passed_mfactor = "m"; *)
 R2 (ng2, GNDOI, VDDOI);
rdp3 #(.l(3.3e-06), .w(4.4e-07), .m(1), .par1(1))
(* integer passed_mfactor = "m"; *)
 R1 (ng1, GNDOI, VDDOI);

endmodule
// Library - IO_CELLS_JIC3V, Cell - APR00DPC, View - cmos_sch
// LAST TIME SAVED: Nov 16 10:55:26 2021
// NETLIST TIME: Feb 12 01:23:42 2024

`worklib IO_CELLS_JIC3V
`view cmos_sch

`timescale 1ns / 1ps
(* cds_ams_schematic *)

module APR00DPC (PAD, GNDI, GNDOI, GNDRI, PSUB, VDD3I, VDDOI, VDDRI);
input  GNDI, GNDOI, GNDRI, PSUB, VDD3I, VDDOI, VDDRI;
inout  PAD;
wire ng;
wire pg;
jio_ne3i_pc IN_1 (.D( PAD ), .B( GNDOI ), .G( ng ), .S( GNDOI ));
jio_ne3i_pc IN_2 (.D( PAD ), .B( GNDOI ), .G( ng ), .S( GNDOI ));
jio_ne3i_pc IN_3 (.D( PAD ), .B( GNDOI ), .G( ng ), .S( GNDOI ));
jio_ne3i_pc IN_4 (.D( PAD ), .B( GNDOI ), .G( ng ), .S( GNDOI ));
jio_ne3i_pc IN_5 (.D( PAD ), .B( GNDOI ), .G( ng ), .S( GNDOI ));
jio_ne3i_pc IN_6 (.D( PAD ), .B( GNDOI ), .G( ng ), .S( GNDOI ));
jio_ne3i_pc IN_7 (.D( PAD ), .B( GNDOI ), .G( ng ), .S( GNDOI ));
jio_ne3i_pc IN_8 (.D( PAD ), .B( GNDOI ), .G( ng ), .S( GNDOI ));
jio_ne3i_pc IN_9 (.D( PAD ), .B( GNDOI ), .G( ng ), .S( GNDOI ));
jio_ne3i_pc IN_10 (.D( PAD ), .B( GNDOI ), .G( ng ), .S( GNDOI ));
jio_ne3i_pc IN_11 (.D( PAD ), .B( GNDOI ), .G( ng ), .S( GNDOI ));
jio_ne3i_pc IN_12 (.D( PAD ), .B( GNDOI ), .G( ng ), .S( GNDOI ));
jio_ne3i_pc IN_13 (.D( PAD ), .B( GNDOI ), .G( ng ), .S( GNDOI ));
jio_ne3i_pc IN_14 (.D( PAD ), .B( GNDOI ), .G( ng ), .S( GNDOI ));
jio_ne3i_pc IN_15 (.D( PAD ), .B( GNDOI ), .G( ng ), .S( GNDOI ));
jio_ne3i_pc IN_16 (.D( PAD ), .B( GNDOI ), .G( ng ), .S( GNDOI ));
jio_ne3i_pc IN_17 (.D( PAD ), .B( GNDOI ), .G( ng ), .S( GNDOI ));
jio_ne3i_pc IN_18 (.D( PAD ), .B( GNDOI ), .G( ng ), .S( GNDOI ));
jio_ne3i_pc IN_19 (.D( PAD ), .B( GNDOI ), .G( ng ), .S( GNDOI ));
jio_ne3i_pc IN_20 (.D( PAD ), .B( GNDOI ), .G( ng ), .S( GNDOI ));
jio_ne3i_pc IN_21 (.D( PAD ), .B( GNDOI ), .G( ng ), .S( GNDOI ));
jio_ne3i_pc IN_22 (.D( PAD ), .B( GNDOI ), .G( ng ), .S( GNDOI ));
jio_ne3i_pc IN_23 (.D( PAD ), .B( GNDOI ), .G( ng ), .S( GNDOI ));
jio_ne3i_pc IN_24 (.D( PAD ), .B( GNDOI ), .G( ng ), .S( GNDOI ));
jio_andio_pc I157 (.PSUB( PSUB ), .PWI( GNDOI ), .DNW( VDDOI ));
jio_pe3i_pc IP_1 (.S( VDDOI ), .G( pg ), .B( VDDOI ), .D( PAD ));
jio_pe3i_pc IP_2 (.S( VDDOI ), .G( pg ), .B( VDDOI ), .D( PAD ));
jio_pe3i_pc IP_3 (.S( VDDOI ), .G( pg ), .B( VDDOI ), .D( PAD ));
jio_pe3i_pc IP_4 (.S( VDDOI ), .G( pg ), .B( VDDOI ), .D( PAD ));
jio_pe3i_pc IP_5 (.S( VDDOI ), .G( pg ), .B( VDDOI ), .D( PAD ));
jio_pe3i_pc IP_6 (.S( VDDOI ), .G( pg ), .B( VDDOI ), .D( PAD ));
jio_pe3i_pc IP_7 (.S( VDDOI ), .G( pg ), .B( VDDOI ), .D( PAD ));
jio_pe3i_pc IP_8 (.S( VDDOI ), .G( pg ), .B( VDDOI ), .D( PAD ));
jio_pe3i_pc IP_9 (.S( VDDOI ), .G( pg ), .B( VDDOI ), .D( PAD ));
jio_pe3i_pc IP_10 (.S( VDDOI ), .G( pg ), .B( VDDOI ), .D( PAD ));
jio_pe3i_pc IP_11 (.S( VDDOI ), .G( pg ), .B( VDDOI ), .D( PAD ));
jio_pe3i_pc IP_12 (.S( VDDOI ), .G( pg ), .B( VDDOI ), .D( PAD ));
jio_pe3i_pc IP_13 (.S( VDDOI ), .G( pg ), .B( VDDOI ), .D( PAD ));
jio_pe3i_pc IP_14 (.S( VDDOI ), .G( pg ), .B( VDDOI ), .D( PAD ));
jio_pe3i_pc IP_15 (.S( VDDOI ), .G( pg ), .B( VDDOI ), .D( PAD ));
jio_pe3i_pc IP_16 (.S( VDDOI ), .G( pg ), .B( VDDOI ), .D( PAD ));
jio_pe3i_pc IP_17 (.S( VDDOI ), .G( pg ), .B( VDDOI ), .D( PAD ));
jio_pe3i_pc IP_18 (.S( VDDOI ), .G( pg ), .B( VDDOI ), .D( PAD ));
jio_pe3i_pc IP_19 (.S( VDDOI ), .G( pg ), .B( VDDOI ), .D( PAD ));
jio_pe3i_pc IP_20 (.S( VDDOI ), .G( pg ), .B( VDDOI ), .D( PAD ));
jio_pe3i_pc IP_21 (.S( VDDOI ), .G( pg ), .B( VDDOI ), .D( PAD ));
jio_pe3i_pc IP_22 (.S( VDDOI ), .G( pg ), .B( VDDOI ), .D( PAD ));
jio_pe3i_pc IP_23 (.S( VDDOI ), .G( pg ), .B( VDDOI ), .D( PAD ));
jio_pe3i_pc IP_24 (.S( VDDOI ), .G( pg ), .B( VDDOI ), .D( PAD ));
jio_pe3i_pc IP_25 (.S( VDDOI ), .G( pg ), .B( VDDOI ), .D( PAD ));
jio_pe3i_pc IP_26 (.S( VDDOI ), .G( pg ), .B( VDDOI ), .D( PAD ));
jio_pe3i_pc IP_27 (.S( VDDOI ), .G( pg ), .B( VDDOI ), .D( PAD ));
jio_pe3i_pc IP_28 (.S( VDDOI ), .G( pg ), .B( VDDOI ), .D( PAD ));
jio_pe3i_pc IP_29 (.S( VDDOI ), .G( pg ), .B( VDDOI ), .D( PAD ));
jio_pe3i_pc IP_30 (.S( VDDOI ), .G( pg ), .B( VDDOI ), .D( PAD ));
jio_pe3i_pc IP_31 (.S( VDDOI ), .G( pg ), .B( VDDOI ), .D( PAD ));
jio_pe3i_pc IP_32 (.S( VDDOI ), .G( pg ), .B( VDDOI ), .D( PAD ));
rdp3 #(.l(3.3e-06), .w(4.4e-07), .m(1), .par1(1))
(* integer passed_mfactor = "m"; *)
 R11 (ng, GNDOI, VDDOI);
rdp3 #(.l(3.3e-06), .w(4.4e-07), .m(1), .par1(1))
(* integer passed_mfactor = "m"; *)
 R0 (VDDOI, pg, VDDOI);

endmodule
// Library - IO_CELLS_JIC3V, Cell - jio_anrdio_pc, View - cmos_sch
// LAST TIME SAVED: Nov 16 02:00:21 2021
// NETLIST TIME: Feb 12 01:23:42 2024

`worklib IO_CELLS_JIC3V
`view cmos_sch

`timescale 1ns / 1ps
(* cds_ams_schematic *)

module jio_anrdio_pc (DNLW, DNW, LPWI, NW, PSUB, PWI, VDN);
input  DNLW, DNW, LPWI, NW, PSUB, PWI, VDN;
ddnwmv #(.area(9.789e-10), .perimeter(0.00016012), .dbv(0), .m(1), .par1(1), .xf_subext(0))
(* integer passed_mfactor = "m"; *)
 D5 (PSUB, DNLW);
ddnwmv #(.area(4.69976e-09), .perimeter(0.00027464), .dbv(0), .m(1), .par1(1), .xf_subext(0))
(* integer passed_mfactor = "m"; *)
 D0 (PSUB, VDN);
ddnwmv #(.area(9.8345e-10), .perimeter(0.00016026), .dbv(0), .m(1), .par1(1), .xf_subext(0))
(* integer passed_mfactor = "m"; *)
 D6 (PSUB, DNW);
dipdnwmv #(.area(4.16648e-09), .perimeter(0.00025864), .dbv(0), .m(1), .par1(1))
(* integer passed_mfactor = "m"; *)
 D1 (PWI, VDN);
dipdnwmv #(.area(2.1664e-10), .perimeter(5.908e-05), .dbv(0), .m(1), .par1(1))
(* integer passed_mfactor = "m"; *)
 D2 (PWI, NW);
dipdnwmv #(.area(1.2696e-10), .perimeter(4.787e-05), .dbv(0), .m(1), .par1(1))
(* integer passed_mfactor = "m"; *)
 D4 (PWI, NW);

endmodule
// Library - IO_CELLS_JIC3V, Cell - APR04DPC, View - cmos_sch
// LAST TIME SAVED: Nov 16 10:56:44 2021
// NETLIST TIME: Feb 12 01:23:42 2024

`worklib IO_CELLS_JIC3V
`view cmos_sch

`timescale 1ns / 1ps
(* cds_ams_schematic *)

module APR04DPC (Y, GNDI, GNDOI, GNDRI, PAD, PSUB, VDD3I, VDDOI, VDDRI);
output  Y;
input  GNDI, GNDOI, GNDRI, PAD, PSUB, VDD3I, VDDOI, VDDRI;
wire ng;
wire rh;
jio_ne3is_pc INS_1 (.D( Y ), .B( GNDOI ), .G( GNDOI ), .S( GNDOI ));
jio_ne3is_pc INS_2 (.D( Y ), .B( GNDOI ), .G( GNDOI ), .S( GNDOI ));
jio_ne3i_pc IN_1 (.D( PAD ), .B( GNDOI ), .G( ng ), .S( GNDOI ));
jio_ne3i_pc IN_2 (.D( PAD ), .B( GNDOI ), .G( ng ), .S( GNDOI ));
jio_ne3i_pc IN_3 (.D( PAD ), .B( GNDOI ), .G( ng ), .S( GNDOI ));
jio_ne3i_pc IN_4 (.D( PAD ), .B( GNDOI ), .G( ng ), .S( GNDOI ));
jio_ne3i_pc IN_5 (.D( PAD ), .B( GNDOI ), .G( ng ), .S( GNDOI ));
jio_ne3i_pc IN_6 (.D( PAD ), .B( GNDOI ), .G( ng ), .S( GNDOI ));
jio_ne3i_pc IN_7 (.D( PAD ), .B( GNDOI ), .G( ng ), .S( GNDOI ));
jio_ne3i_pc IN_8 (.D( PAD ), .B( GNDOI ), .G( ng ), .S( GNDOI ));
jio_ne3i_pc IN_9 (.D( PAD ), .B( GNDOI ), .G( ng ), .S( GNDOI ));
jio_ne3i_pc IN_10 (.D( PAD ), .B( GNDOI ), .G( ng ), .S( GNDOI ));
jio_ne3i_pc IN_11 (.D( PAD ), .B( GNDOI ), .G( ng ), .S( GNDOI ));
jio_ne3i_pc IN_12 (.D( PAD ), .B( GNDOI ), .G( ng ), .S( GNDOI ));
jio_ne3i_pc IN_13 (.D( PAD ), .B( GNDOI ), .G( ng ), .S( GNDOI ));
jio_ne3i_pc IN_14 (.D( PAD ), .B( GNDOI ), .G( ng ), .S( GNDOI ));
jio_ne3i_pc IN_15 (.D( PAD ), .B( GNDOI ), .G( ng ), .S( GNDOI ));
jio_ne3i_pc IN_16 (.D( PAD ), .B( GNDOI ), .G( ng ), .S( GNDOI ));
jio_ne3i_pc IN_17 (.D( PAD ), .B( GNDOI ), .G( ng ), .S( GNDOI ));
jio_ne3i_pc IN_18 (.D( PAD ), .B( GNDOI ), .G( ng ), .S( GNDOI ));
jio_ne3i_pc IN_19 (.D( PAD ), .B( GNDOI ), .G( ng ), .S( GNDOI ));
jio_ne3i_pc IN_20 (.D( PAD ), .B( GNDOI ), .G( ng ), .S( GNDOI ));
jio_ne3i_pc IN_21 (.D( PAD ), .B( GNDOI ), .G( ng ), .S( GNDOI ));
jio_ne3i_pc IN_22 (.D( PAD ), .B( GNDOI ), .G( ng ), .S( GNDOI ));
jio_ne3i_pc IN_23 (.D( PAD ), .B( GNDOI ), .G( ng ), .S( GNDOI ));
jio_ne3i_pc IN_24 (.D( PAD ), .B( GNDOI ), .G( ng ), .S( GNDOI ));
jio_resp_pc I3 (.RH( rh ), .VDDO( VDDOI ), .GNDO( GNDOI ));
jio_pe3i_pc IP_1 (.S( VDDOI ), .G( rh ), .B( VDDOI ), .D( PAD ));
jio_pe3i_pc IP_2 (.S( VDDOI ), .G( rh ), .B( VDDOI ), .D( PAD ));
jio_pe3i_pc IP_3 (.S( VDDOI ), .G( rh ), .B( VDDOI ), .D( PAD ));
jio_pe3i_pc IP_4 (.S( VDDOI ), .G( rh ), .B( VDDOI ), .D( PAD ));
jio_pe3i_pc IP_5 (.S( VDDOI ), .G( rh ), .B( VDDOI ), .D( PAD ));
jio_pe3i_pc IP_6 (.S( VDDOI ), .G( rh ), .B( VDDOI ), .D( PAD ));
jio_pe3i_pc IP_7 (.S( VDDOI ), .G( rh ), .B( VDDOI ), .D( PAD ));
jio_pe3i_pc IP_8 (.S( VDDOI ), .G( rh ), .B( VDDOI ), .D( PAD ));
jio_pe3i_pc IP_9 (.S( VDDOI ), .G( rh ), .B( VDDOI ), .D( PAD ));
jio_pe3i_pc IP_10 (.S( VDDOI ), .G( rh ), .B( VDDOI ), .D( PAD ));
jio_pe3i_pc IP_11 (.S( VDDOI ), .G( rh ), .B( VDDOI ), .D( PAD ));
jio_pe3i_pc IP_12 (.S( VDDOI ), .G( rh ), .B( VDDOI ), .D( PAD ));
jio_pe3i_pc IP_13 (.S( VDDOI ), .G( rh ), .B( VDDOI ), .D( PAD ));
jio_pe3i_pc IP_14 (.S( VDDOI ), .G( rh ), .B( VDDOI ), .D( PAD ));
jio_pe3i_pc IP_15 (.S( VDDOI ), .G( rh ), .B( VDDOI ), .D( PAD ));
jio_pe3i_pc IP_16 (.S( VDDOI ), .G( rh ), .B( VDDOI ), .D( PAD ));
jio_pe3i_pc IP_17 (.S( VDDOI ), .G( rh ), .B( VDDOI ), .D( PAD ));
jio_pe3i_pc IP_18 (.S( VDDOI ), .G( rh ), .B( VDDOI ), .D( PAD ));
jio_pe3i_pc IP_19 (.S( VDDOI ), .G( rh ), .B( VDDOI ), .D( PAD ));
jio_pe3i_pc IP_20 (.S( VDDOI ), .G( rh ), .B( VDDOI ), .D( PAD ));
jio_pe3i_pc IP_21 (.S( VDDOI ), .G( rh ), .B( VDDOI ), .D( PAD ));
jio_pe3i_pc IP_22 (.S( VDDOI ), .G( rh ), .B( VDDOI ), .D( PAD ));
jio_pe3i_pc IP_23 (.S( VDDOI ), .G( rh ), .B( VDDOI ), .D( PAD ));
jio_pe3i_pc IP_24 (.S( VDDOI ), .G( rh ), .B( VDDOI ), .D( PAD ));
jio_anrdio_pc I157 (.NW( VDDOI ), .PSUB( PSUB ), .LPWI( GNDI ), .VDN( VDDOI ), .PWI( GNDOI ), .DNW( VDDOI ), .DNLW( VDD3I ));
ne3i #(.w(1.2e-06), .l(4e-07), .as(5.76e-13), .ad(5.76e-13), .ps(3.36e-06), .pd(3.36e-06), .nrs(0.225), .nrd(0.225), .m((1)*(1)), .par1((1)*(1)))
(* integer passed_mfactor = "m"; *)
 M2 (ng, rh, GNDOI, GNDOI);
pe3i #(.w(1.2e-05), .l(3.5e-07), .as(5.76e-12), .ad(3.24e-12), .ps(2.496e-05), .pd(1.254e-05), .nrs(0.0225), .nrd(0.0225), .m((1)*(2)), .par1((1)*(2)))
(* integer passed_mfactor = "m"; *)
 M3 (Y, VDDOI, VDDOI, VDDOI);
rpp1 #(.l(2.2e-06), .w(2e-06), .m(1), .par1(1))
(* integer passed_mfactor = "m"; *)
 R1 (PAD, Y);

endmodule
// Library - HV_CELLS, Cell - ioh_iscrd2_4x100, View - schematic
// LAST TIME SAVED: Feb 25 05:55:54 2015
// NETLIST TIME: Feb 12 01:23:42 2024

`worklib HV_CELLS
`view schematic

`timescale 1ns / 1ps
(* cds_ams_schematic *)

module ioh_iscrd2_4x100 (A, Gn, Gp, K, Sub);
inout  A, Gn, Gp, K, Sub;
dnpdd_scr #(.area(5.36386e-10), .perimeter(0.00040956), .dbv(0), .m(1))
(* integer passed_mfactor = "m"; *)
 D1 (Gp, K);
dpdd_scr #(.area(2.19633e-09), .perimeter(0.00045716), .dbv(0), .m(1))
(* integer passed_mfactor = "m"; *)
 D2 (Gp, Gn);
dpdnw #(.area(1.89063e-10), .perimeter(0.00020378), .dbv(0), .m(4), .par1(4))
(* integer passed_mfactor = "m"; *)
 D0 (A, Gn);
ddnw #(.area(6.92224e-09), .perimeter(0.00035917), .dbv(0), .m(1), .par1(1), .xf_subext(0))
(* integer passed_mfactor = "m"; *)
 D_Guard (Sub, Gn);

endmodule
// Library - HV_CELLS, Cell - ioh_dhpw_2x100, View - schematic
// LAST TIME SAVED: Feb 25 05:55:51 2015
// NETLIST TIME: Feb 12 01:23:42 2024

`worklib HV_CELLS
`view schematic

`timescale 1ns / 1ps
(* cds_ams_schematic *)

module ioh_dhpw_2x100 (A, K, Sub);
inout  A, K, Sub;
ddnw #(.area(3.37852e-09), .perimeter(0.0002844), .dbv(0), .m(1), .par1(1), .xf_subext(0))
(* integer passed_mfactor = "m"; *)
 D0 (Sub, K);
dhpw #(.area(3.87893e-10), .perimeter(0.000207812), .dbv(0), .m(2), .par1(2))
(* integer passed_mfactor = "m"; *)
 D1 (A, K);

endmodule
// Library - HV_CELLS, Cell - ioh_dhpw_2x100_stack3, View - schematic
// LAST TIME SAVED: Feb 25 05:55:51 2015
// NETLIST TIME: Feb 12 01:23:42 2024

`worklib HV_CELLS
`view schematic

`timescale 1ns / 1ps
(* cds_ams_schematic *)

module ioh_dhpw_2x100_stack3 (A_l, K_h, Sub);
inout  A_l, K_h, Sub;
wire net20;
wire net14;
ioh_dhpw_2x100 I0 (.A( A_l ), .K( net20 ), .Sub( Sub ));
ioh_dhpw_2x100 I2 (.A( net14 ), .K( K_h ), .Sub( Sub ));
ioh_dhpw_2x100 I1 (.A( net20 ), .K( net14 ), .Sub( Sub ));

endmodule
// Library - HV_CELLS, Cell - ioh_pe3isab_15_04, View - schematic
// LAST TIME SAVED: Feb 25 05:55:55 2015
// NETLIST TIME: Feb 12 01:23:42 2024

`worklib HV_CELLS
`view schematic

`timescale 1ns / 1ps
(* cds_ams_schematic *)

module ioh_pe3isab_15_04 (B, D, G, S);
inout  B, D, G, S;
pe3i #(.w(1.5e-05), .l(4e-07), .as(7.2e-12), .ad(7.2e-12), .ps(3.096e-05), .pd(3.096e-05), .nrs(0.018), .nrd(0.018), .m((1)*(1)), .par1((1)*(1)))
(* integer passed_mfactor = "m"; *)
 MPX (net17, G, S, B);
rdp3 #(.l(4.3e-07), .w(1.5e-05), .m(1), .par1(1))
(* integer passed_mfactor = "m"; *)
 R0 (net17, D, B);

endmodule
// Library - HV_CELLS, Cell - ioh_pe3isabhv_1050gcr, View - schematic
// LAST TIME SAVED: Feb 25 05:55:55 2015
// NETLIST TIME: Feb 12 01:23:42 2024

`worklib HV_CELLS
`view schematic

`timescale 1ns / 1ps
(* cds_ams_schematic *)

module ioh_pe3isabhv_1050gcr (D, SB, Sub);
inout  D, SB, Sub;
wire net20;
ioh_pe3isab_15_04 MP_1 (.D( D ), .B( SB ), .G( net20 ), .S( SB ));
ioh_pe3isab_15_04 MP_2 (.D( D ), .B( SB ), .G( net20 ), .S( SB ));
ioh_pe3isab_15_04 MP_3 (.D( D ), .B( SB ), .G( net20 ), .S( SB ));
ioh_pe3isab_15_04 MP_4 (.D( D ), .B( SB ), .G( net20 ), .S( SB ));
ioh_pe3isab_15_04 MP_5 (.D( D ), .B( SB ), .G( net20 ), .S( SB ));
ioh_pe3isab_15_04 MP_6 (.D( D ), .B( SB ), .G( net20 ), .S( SB ));
ioh_pe3isab_15_04 MP_7 (.D( D ), .B( SB ), .G( net20 ), .S( SB ));
ioh_pe3isab_15_04 MP_8 (.D( D ), .B( SB ), .G( net20 ), .S( SB ));
ioh_pe3isab_15_04 MP_9 (.D( D ), .B( SB ), .G( net20 ), .S( SB ));
ioh_pe3isab_15_04 MP_10 (.D( D ), .B( SB ), .G( net20 ), .S( SB ));
ioh_pe3isab_15_04 MP_11 (.D( D ), .B( SB ), .G( net20 ), .S( SB ));
ioh_pe3isab_15_04 MP_12 (.D( D ), .B( SB ), .G( net20 ), .S( SB ));
ioh_pe3isab_15_04 MP_13 (.D( D ), .B( SB ), .G( net20 ), .S( SB ));
ioh_pe3isab_15_04 MP_14 (.D( D ), .B( SB ), .G( net20 ), .S( SB ));
ioh_pe3isab_15_04 MP_15 (.D( D ), .B( SB ), .G( net20 ), .S( SB ));
ioh_pe3isab_15_04 MP_16 (.D( D ), .B( SB ), .G( net20 ), .S( SB ));
ioh_pe3isab_15_04 MP_17 (.D( D ), .B( SB ), .G( net20 ), .S( SB ));
ioh_pe3isab_15_04 MP_18 (.D( D ), .B( SB ), .G( net20 ), .S( SB ));
ioh_pe3isab_15_04 MP_19 (.D( D ), .B( SB ), .G( net20 ), .S( SB ));
ioh_pe3isab_15_04 MP_20 (.D( D ), .B( SB ), .G( net20 ), .S( SB ));
ioh_pe3isab_15_04 MP_21 (.D( D ), .B( SB ), .G( net20 ), .S( SB ));
ioh_pe3isab_15_04 MP_22 (.D( D ), .B( SB ), .G( net20 ), .S( SB ));
ioh_pe3isab_15_04 MP_23 (.D( D ), .B( SB ), .G( net20 ), .S( SB ));
ioh_pe3isab_15_04 MP_24 (.D( D ), .B( SB ), .G( net20 ), .S( SB ));
ioh_pe3isab_15_04 MP_25 (.D( D ), .B( SB ), .G( net20 ), .S( SB ));
ioh_pe3isab_15_04 MP_26 (.D( D ), .B( SB ), .G( net20 ), .S( SB ));
ioh_pe3isab_15_04 MP_27 (.D( D ), .B( SB ), .G( net20 ), .S( SB ));
ioh_pe3isab_15_04 MP_28 (.D( D ), .B( SB ), .G( net20 ), .S( SB ));
ioh_pe3isab_15_04 MP_29 (.D( D ), .B( SB ), .G( net20 ), .S( SB ));
ioh_pe3isab_15_04 MP_30 (.D( D ), .B( SB ), .G( net20 ), .S( SB ));
ioh_pe3isab_15_04 MP_31 (.D( D ), .B( SB ), .G( net20 ), .S( SB ));
ioh_pe3isab_15_04 MP_32 (.D( D ), .B( SB ), .G( net20 ), .S( SB ));
ioh_pe3isab_15_04 MP_33 (.D( D ), .B( SB ), .G( net20 ), .S( SB ));
ioh_pe3isab_15_04 MP_34 (.D( D ), .B( SB ), .G( net20 ), .S( SB ));
ioh_pe3isab_15_04 MP_35 (.D( D ), .B( SB ), .G( net20 ), .S( SB ));
ioh_pe3isab_15_04 MP_36 (.D( D ), .B( SB ), .G( net20 ), .S( SB ));
ioh_pe3isab_15_04 MP_37 (.D( D ), .B( SB ), .G( net20 ), .S( SB ));
ioh_pe3isab_15_04 MP_38 (.D( D ), .B( SB ), .G( net20 ), .S( SB ));
ioh_pe3isab_15_04 MP_39 (.D( D ), .B( SB ), .G( net20 ), .S( SB ));
ioh_pe3isab_15_04 MP_40 (.D( D ), .B( SB ), .G( net20 ), .S( SB ));
ioh_pe3isab_15_04 MP_41 (.D( D ), .B( SB ), .G( net20 ), .S( SB ));
ioh_pe3isab_15_04 MP_42 (.D( D ), .B( SB ), .G( net20 ), .S( SB ));
ioh_pe3isab_15_04 MP_43 (.D( D ), .B( SB ), .G( net20 ), .S( SB ));
ioh_pe3isab_15_04 MP_44 (.D( D ), .B( SB ), .G( net20 ), .S( SB ));
ioh_pe3isab_15_04 MP_45 (.D( D ), .B( SB ), .G( net20 ), .S( SB ));
ioh_pe3isab_15_04 MP_46 (.D( D ), .B( SB ), .G( net20 ), .S( SB ));
ioh_pe3isab_15_04 MP_47 (.D( D ), .B( SB ), .G( net20 ), .S( SB ));
ioh_pe3isab_15_04 MP_48 (.D( D ), .B( SB ), .G( net20 ), .S( SB ));
ioh_pe3isab_15_04 MP_49 (.D( D ), .B( SB ), .G( net20 ), .S( SB ));
ioh_pe3isab_15_04 MP_50 (.D( D ), .B( SB ), .G( net20 ), .S( SB ));
ioh_pe3isab_15_04 MP_51 (.D( D ), .B( SB ), .G( net20 ), .S( SB ));
ioh_pe3isab_15_04 MP_52 (.D( D ), .B( SB ), .G( net20 ), .S( SB ));
ioh_pe3isab_15_04 MP_53 (.D( D ), .B( SB ), .G( net20 ), .S( SB ));
ioh_pe3isab_15_04 MP_54 (.D( D ), .B( SB ), .G( net20 ), .S( SB ));
ioh_pe3isab_15_04 MP_55 (.D( D ), .B( SB ), .G( net20 ), .S( SB ));
ioh_pe3isab_15_04 MP_56 (.D( D ), .B( SB ), .G( net20 ), .S( SB ));
ioh_pe3isab_15_04 MP_57 (.D( D ), .B( SB ), .G( net20 ), .S( SB ));
ioh_pe3isab_15_04 MP_58 (.D( D ), .B( SB ), .G( net20 ), .S( SB ));
ioh_pe3isab_15_04 MP_59 (.D( D ), .B( SB ), .G( net20 ), .S( SB ));
ioh_pe3isab_15_04 MP_60 (.D( D ), .B( SB ), .G( net20 ), .S( SB ));
ioh_pe3isab_15_04 MP_61 (.D( D ), .B( SB ), .G( net20 ), .S( SB ));
ioh_pe3isab_15_04 MP_62 (.D( D ), .B( SB ), .G( net20 ), .S( SB ));
ioh_pe3isab_15_04 MP_63 (.D( D ), .B( SB ), .G( net20 ), .S( SB ));
ioh_pe3isab_15_04 MP_64 (.D( D ), .B( SB ), .G( net20 ), .S( SB ));
ioh_pe3isab_15_04 MP_65 (.D( D ), .B( SB ), .G( net20 ), .S( SB ));
ioh_pe3isab_15_04 MP_66 (.D( D ), .B( SB ), .G( net20 ), .S( SB ));
ioh_pe3isab_15_04 MP_67 (.D( D ), .B( SB ), .G( net20 ), .S( SB ));
ioh_pe3isab_15_04 MP_68 (.D( D ), .B( SB ), .G( net20 ), .S( SB ));
ioh_pe3isab_15_04 MP_69 (.D( D ), .B( SB ), .G( net20 ), .S( SB ));
ioh_pe3isab_15_04 MP_70 (.D( D ), .B( SB ), .G( net20 ), .S( SB ));
dp3 #(.area(9.89102e-12), .perimeter(1.32e-06), .dbv(0), .m(1), .par1(1))
(* integer passed_mfactor = "m"; *)
 MD_1 (D, SB);
dp3 #(.area(9.89102e-12), .perimeter(1.32e-06), .dbv(0), .m(1), .par1(1))
(* integer passed_mfactor = "m"; *)
 MD_2 (D, SB);
dp3 #(.area(9.89102e-12), .perimeter(1.32e-06), .dbv(0), .m(1), .par1(1))
(* integer passed_mfactor = "m"; *)
 MD_3 (D, SB);
dp3 #(.area(9.89102e-12), .perimeter(1.32e-06), .dbv(0), .m(1), .par1(1))
(* integer passed_mfactor = "m"; *)
 MD_4 (D, SB);
dp3 #(.area(9.89102e-12), .perimeter(1.32e-06), .dbv(0), .m(1), .par1(1))
(* integer passed_mfactor = "m"; *)
 MD_5 (D, SB);
dp3 #(.area(9.89102e-12), .perimeter(1.32e-06), .dbv(0), .m(1), .par1(1))
(* integer passed_mfactor = "m"; *)
 MD_6 (D, SB);
dp3 #(.area(9.89102e-12), .perimeter(1.32e-06), .dbv(0), .m(1), .par1(1))
(* integer passed_mfactor = "m"; *)
 MD_7 (D, SB);
dp3 #(.area(9.89102e-12), .perimeter(1.32e-06), .dbv(0), .m(1), .par1(1))
(* integer passed_mfactor = "m"; *)
 MD_8 (D, SB);
dp3 #(.area(9.89102e-12), .perimeter(1.32e-06), .dbv(0), .m(1), .par1(1))
(* integer passed_mfactor = "m"; *)
 MD_9 (D, SB);
dp3 #(.area(9.89102e-12), .perimeter(1.32e-06), .dbv(0), .m(1), .par1(1))
(* integer passed_mfactor = "m"; *)
 MD_10 (D, SB);
dp3 #(.area(9.89102e-12), .perimeter(1.32e-06), .dbv(0), .m(1), .par1(1))
(* integer passed_mfactor = "m"; *)
 MD_11 (D, SB);
dp3 #(.area(9.89102e-12), .perimeter(1.32e-06), .dbv(0), .m(1), .par1(1))
(* integer passed_mfactor = "m"; *)
 MD_12 (D, SB);
dp3 #(.area(9.89102e-12), .perimeter(1.32e-06), .dbv(0), .m(1), .par1(1))
(* integer passed_mfactor = "m"; *)
 MD_13 (D, SB);
dp3 #(.area(9.89102e-12), .perimeter(1.32e-06), .dbv(0), .m(1), .par1(1))
(* integer passed_mfactor = "m"; *)
 MD_14 (D, SB);
dp3 #(.area(9.89102e-12), .perimeter(1.32e-06), .dbv(0), .m(1), .par1(1))
(* integer passed_mfactor = "m"; *)
 MD_15 (D, SB);
dp3 #(.area(9.89102e-12), .perimeter(1.32e-06), .dbv(0), .m(1), .par1(1))
(* integer passed_mfactor = "m"; *)
 MD_16 (D, SB);
dp3 #(.area(9.89102e-12), .perimeter(1.32e-06), .dbv(0), .m(1), .par1(1))
(* integer passed_mfactor = "m"; *)
 MD_17 (D, SB);
dp3 #(.area(9.89102e-12), .perimeter(1.32e-06), .dbv(0), .m(1), .par1(1))
(* integer passed_mfactor = "m"; *)
 MD_18 (D, SB);
dp3 #(.area(9.89102e-12), .perimeter(1.32e-06), .dbv(0), .m(1), .par1(1))
(* integer passed_mfactor = "m"; *)
 MD_19 (D, SB);
dp3 #(.area(9.89102e-12), .perimeter(1.32e-06), .dbv(0), .m(1), .par1(1))
(* integer passed_mfactor = "m"; *)
 MD_20 (D, SB);
dp3 #(.area(9.89102e-12), .perimeter(1.32e-06), .dbv(0), .m(1), .par1(1))
(* integer passed_mfactor = "m"; *)
 MD_21 (D, SB);
dp3 #(.area(9.89102e-12), .perimeter(1.32e-06), .dbv(0), .m(1), .par1(1))
(* integer passed_mfactor = "m"; *)
 MD_22 (D, SB);
dp3 #(.area(9.89102e-12), .perimeter(1.32e-06), .dbv(0), .m(1), .par1(1))
(* integer passed_mfactor = "m"; *)
 MD_23 (D, SB);
dp3 #(.area(9.89102e-12), .perimeter(1.32e-06), .dbv(0), .m(1), .par1(1))
(* integer passed_mfactor = "m"; *)
 MD_24 (D, SB);
dp3 #(.area(9.89102e-12), .perimeter(1.32e-06), .dbv(0), .m(1), .par1(1))
(* integer passed_mfactor = "m"; *)
 MD_25 (D, SB);
dp3 #(.area(9.89102e-12), .perimeter(1.32e-06), .dbv(0), .m(1), .par1(1))
(* integer passed_mfactor = "m"; *)
 MD_26 (D, SB);
dp3 #(.area(9.89102e-12), .perimeter(1.32e-06), .dbv(0), .m(1), .par1(1))
(* integer passed_mfactor = "m"; *)
 MD_27 (D, SB);
dp3 #(.area(9.89102e-12), .perimeter(1.32e-06), .dbv(0), .m(1), .par1(1))
(* integer passed_mfactor = "m"; *)
 MD_28 (D, SB);
dp3 #(.area(9.89102e-12), .perimeter(1.32e-06), .dbv(0), .m(1), .par1(1))
(* integer passed_mfactor = "m"; *)
 MD_29 (D, SB);
dp3 #(.area(9.89102e-12), .perimeter(1.32e-06), .dbv(0), .m(1), .par1(1))
(* integer passed_mfactor = "m"; *)
 MD_30 (D, SB);
dp3 #(.area(9.89102e-12), .perimeter(1.32e-06), .dbv(0), .m(1), .par1(1))
(* integer passed_mfactor = "m"; *)
 MD_31 (D, SB);
dp3 #(.area(9.89102e-12), .perimeter(1.32e-06), .dbv(0), .m(1), .par1(1))
(* integer passed_mfactor = "m"; *)
 MD_32 (D, SB);
dp3 #(.area(9.89102e-12), .perimeter(1.32e-06), .dbv(0), .m(1), .par1(1))
(* integer passed_mfactor = "m"; *)
 MD_33 (D, SB);
dp3 #(.area(9.89102e-12), .perimeter(1.32e-06), .dbv(0), .m(1), .par1(1))
(* integer passed_mfactor = "m"; *)
 MD_34 (D, SB);
dp3 #(.area(9.89102e-12), .perimeter(1.32e-06), .dbv(0), .m(1), .par1(1))
(* integer passed_mfactor = "m"; *)
 MD_35 (D, SB);
ddnw #(.area(3.10026e-09), .perimeter(0.0002852), .dbv(0), .m(1), .par1(1), .xf_subext(0))
(* integer passed_mfactor = "m"; *)
 D0 (Sub, SB);
rnp1 #(.l(2.55e-05), .w(4.2e-07), .m(1), .par1(1))
(* integer passed_mfactor = "m"; *)
 R0 (SB, net20);

endmodule
// Library - HV_CELLS, Cell - ioh_pmbsab_15_10, View - schematic
// LAST TIME SAVED: Feb 25 05:55:56 2015
// NETLIST TIME: Feb 12 01:23:42 2024

`worklib HV_CELLS
`view schematic

`timescale 1ns / 1ps
(* cds_ams_schematic *)

module ioh_pmbsab_15_10 (B, D, G, S);
inout  B, D, G, S;
pmb #(.w(1.512e-05), .l(1e-06), .as(7.2576e-12), .ad(7.2576e-12), .ps(3.12e-05), .pd(3.12e-05), .nrs(0.0178571), .nrd(0.0178571), .m((1)*(1)), .par1((1)*(1)))
(* integer passed_mfactor = "m"; *)
 MPX (D, G, S, B);

endmodule
// Library - HV_CELLS, Cell - ioh_pmbsabhv_750, View - schematic
// LAST TIME SAVED: Feb 25 05:55:57 2015
// NETLIST TIME: Feb 12 01:23:42 2024

`worklib HV_CELLS
`view schematic

`timescale 1ns / 1ps
(* cds_ams_schematic *)

module ioh_pmbsabhv_750 (D, GSB, Sub);
inout  D, GSB, Sub;
wire [0:49] net20;
ioh_pmbsab_15_10 MP_1 (.D( net20[0] ), .B( GSB ), .G( GSB ), .S( GSB ));
ioh_pmbsab_15_10 MP_2 (.D( net20[1] ), .B( GSB ), .G( GSB ), .S( GSB ));
ioh_pmbsab_15_10 MP_3 (.D( net20[2] ), .B( GSB ), .G( GSB ), .S( GSB ));
ioh_pmbsab_15_10 MP_4 (.D( net20[3] ), .B( GSB ), .G( GSB ), .S( GSB ));
ioh_pmbsab_15_10 MP_5 (.D( net20[4] ), .B( GSB ), .G( GSB ), .S( GSB ));
ioh_pmbsab_15_10 MP_6 (.D( net20[5] ), .B( GSB ), .G( GSB ), .S( GSB ));
ioh_pmbsab_15_10 MP_7 (.D( net20[6] ), .B( GSB ), .G( GSB ), .S( GSB ));
ioh_pmbsab_15_10 MP_8 (.D( net20[7] ), .B( GSB ), .G( GSB ), .S( GSB ));
ioh_pmbsab_15_10 MP_9 (.D( net20[8] ), .B( GSB ), .G( GSB ), .S( GSB ));
ioh_pmbsab_15_10 MP_10 (.D( net20[9] ), .B( GSB ), .G( GSB ), .S( GSB ));
ioh_pmbsab_15_10 MP_11 (.D( net20[10] ), .B( GSB ), .G( GSB ), .S( GSB ));
ioh_pmbsab_15_10 MP_12 (.D( net20[11] ), .B( GSB ), .G( GSB ), .S( GSB ));
ioh_pmbsab_15_10 MP_13 (.D( net20[12] ), .B( GSB ), .G( GSB ), .S( GSB ));
ioh_pmbsab_15_10 MP_14 (.D( net20[13] ), .B( GSB ), .G( GSB ), .S( GSB ));
ioh_pmbsab_15_10 MP_15 (.D( net20[14] ), .B( GSB ), .G( GSB ), .S( GSB ));
ioh_pmbsab_15_10 MP_16 (.D( net20[15] ), .B( GSB ), .G( GSB ), .S( GSB ));
ioh_pmbsab_15_10 MP_17 (.D( net20[16] ), .B( GSB ), .G( GSB ), .S( GSB ));
ioh_pmbsab_15_10 MP_18 (.D( net20[17] ), .B( GSB ), .G( GSB ), .S( GSB ));
ioh_pmbsab_15_10 MP_19 (.D( net20[18] ), .B( GSB ), .G( GSB ), .S( GSB ));
ioh_pmbsab_15_10 MP_20 (.D( net20[19] ), .B( GSB ), .G( GSB ), .S( GSB ));
ioh_pmbsab_15_10 MP_21 (.D( net20[20] ), .B( GSB ), .G( GSB ), .S( GSB ));
ioh_pmbsab_15_10 MP_22 (.D( net20[21] ), .B( GSB ), .G( GSB ), .S( GSB ));
ioh_pmbsab_15_10 MP_23 (.D( net20[22] ), .B( GSB ), .G( GSB ), .S( GSB ));
ioh_pmbsab_15_10 MP_24 (.D( net20[23] ), .B( GSB ), .G( GSB ), .S( GSB ));
ioh_pmbsab_15_10 MP_25 (.D( net20[24] ), .B( GSB ), .G( GSB ), .S( GSB ));
ioh_pmbsab_15_10 MP_26 (.D( net20[25] ), .B( GSB ), .G( GSB ), .S( GSB ));
ioh_pmbsab_15_10 MP_27 (.D( net20[26] ), .B( GSB ), .G( GSB ), .S( GSB ));
ioh_pmbsab_15_10 MP_28 (.D( net20[27] ), .B( GSB ), .G( GSB ), .S( GSB ));
ioh_pmbsab_15_10 MP_29 (.D( net20[28] ), .B( GSB ), .G( GSB ), .S( GSB ));
ioh_pmbsab_15_10 MP_30 (.D( net20[29] ), .B( GSB ), .G( GSB ), .S( GSB ));
ioh_pmbsab_15_10 MP_31 (.D( net20[30] ), .B( GSB ), .G( GSB ), .S( GSB ));
ioh_pmbsab_15_10 MP_32 (.D( net20[31] ), .B( GSB ), .G( GSB ), .S( GSB ));
ioh_pmbsab_15_10 MP_33 (.D( net20[32] ), .B( GSB ), .G( GSB ), .S( GSB ));
ioh_pmbsab_15_10 MP_34 (.D( net20[33] ), .B( GSB ), .G( GSB ), .S( GSB ));
ioh_pmbsab_15_10 MP_35 (.D( net20[34] ), .B( GSB ), .G( GSB ), .S( GSB ));
ioh_pmbsab_15_10 MP_36 (.D( net20[35] ), .B( GSB ), .G( GSB ), .S( GSB ));
ioh_pmbsab_15_10 MP_37 (.D( net20[36] ), .B( GSB ), .G( GSB ), .S( GSB ));
ioh_pmbsab_15_10 MP_38 (.D( net20[37] ), .B( GSB ), .G( GSB ), .S( GSB ));
ioh_pmbsab_15_10 MP_39 (.D( net20[38] ), .B( GSB ), .G( GSB ), .S( GSB ));
ioh_pmbsab_15_10 MP_40 (.D( net20[39] ), .B( GSB ), .G( GSB ), .S( GSB ));
ioh_pmbsab_15_10 MP_41 (.D( net20[40] ), .B( GSB ), .G( GSB ), .S( GSB ));
ioh_pmbsab_15_10 MP_42 (.D( net20[41] ), .B( GSB ), .G( GSB ), .S( GSB ));
ioh_pmbsab_15_10 MP_43 (.D( net20[42] ), .B( GSB ), .G( GSB ), .S( GSB ));
ioh_pmbsab_15_10 MP_44 (.D( net20[43] ), .B( GSB ), .G( GSB ), .S( GSB ));
ioh_pmbsab_15_10 MP_45 (.D( net20[44] ), .B( GSB ), .G( GSB ), .S( GSB ));
ioh_pmbsab_15_10 MP_46 (.D( net20[45] ), .B( GSB ), .G( GSB ), .S( GSB ));
ioh_pmbsab_15_10 MP_47 (.D( net20[46] ), .B( GSB ), .G( GSB ), .S( GSB ));
ioh_pmbsab_15_10 MP_48 (.D( net20[47] ), .B( GSB ), .G( GSB ), .S( GSB ));
ioh_pmbsab_15_10 MP_49 (.D( net20[48] ), .B( GSB ), .G( GSB ), .S( GSB ));
ioh_pmbsab_15_10 MP_50 (.D( net20[49] ), .B( GSB ), .G( GSB ), .S( GSB ));
rdp_io #(.l(5.1e-07), .w(1.5e-05), .m(1), .par1(1), .xf_subext(0))
(* integer passed_mfactor = "m"; *)
 R0_1 (net20[0], D, GSB);
rdp_io #(.l(5.1e-07), .w(1.5e-05), .m(1), .par1(1), .xf_subext(0))
(* integer passed_mfactor = "m"; *)
 R0_2 (net20[1], D, GSB);
rdp_io #(.l(5.1e-07), .w(1.5e-05), .m(1), .par1(1), .xf_subext(0))
(* integer passed_mfactor = "m"; *)
 R0_3 (net20[2], D, GSB);
rdp_io #(.l(5.1e-07), .w(1.5e-05), .m(1), .par1(1), .xf_subext(0))
(* integer passed_mfactor = "m"; *)
 R0_4 (net20[3], D, GSB);
rdp_io #(.l(5.1e-07), .w(1.5e-05), .m(1), .par1(1), .xf_subext(0))
(* integer passed_mfactor = "m"; *)
 R0_5 (net20[4], D, GSB);
rdp_io #(.l(5.1e-07), .w(1.5e-05), .m(1), .par1(1), .xf_subext(0))
(* integer passed_mfactor = "m"; *)
 R0_6 (net20[5], D, GSB);
rdp_io #(.l(5.1e-07), .w(1.5e-05), .m(1), .par1(1), .xf_subext(0))
(* integer passed_mfactor = "m"; *)
 R0_7 (net20[6], D, GSB);
rdp_io #(.l(5.1e-07), .w(1.5e-05), .m(1), .par1(1), .xf_subext(0))
(* integer passed_mfactor = "m"; *)
 R0_8 (net20[7], D, GSB);
rdp_io #(.l(5.1e-07), .w(1.5e-05), .m(1), .par1(1), .xf_subext(0))
(* integer passed_mfactor = "m"; *)
 R0_9 (net20[8], D, GSB);
rdp_io #(.l(5.1e-07), .w(1.5e-05), .m(1), .par1(1), .xf_subext(0))
(* integer passed_mfactor = "m"; *)
 R0_10 (net20[9], D, GSB);
rdp_io #(.l(5.1e-07), .w(1.5e-05), .m(1), .par1(1), .xf_subext(0))
(* integer passed_mfactor = "m"; *)
 R0_11 (net20[10], D, GSB);
rdp_io #(.l(5.1e-07), .w(1.5e-05), .m(1), .par1(1), .xf_subext(0))
(* integer passed_mfactor = "m"; *)
 R0_12 (net20[11], D, GSB);
rdp_io #(.l(5.1e-07), .w(1.5e-05), .m(1), .par1(1), .xf_subext(0))
(* integer passed_mfactor = "m"; *)
 R0_13 (net20[12], D, GSB);
rdp_io #(.l(5.1e-07), .w(1.5e-05), .m(1), .par1(1), .xf_subext(0))
(* integer passed_mfactor = "m"; *)
 R0_14 (net20[13], D, GSB);
rdp_io #(.l(5.1e-07), .w(1.5e-05), .m(1), .par1(1), .xf_subext(0))
(* integer passed_mfactor = "m"; *)
 R0_15 (net20[14], D, GSB);
rdp_io #(.l(5.1e-07), .w(1.5e-05), .m(1), .par1(1), .xf_subext(0))
(* integer passed_mfactor = "m"; *)
 R0_16 (net20[15], D, GSB);
rdp_io #(.l(5.1e-07), .w(1.5e-05), .m(1), .par1(1), .xf_subext(0))
(* integer passed_mfactor = "m"; *)
 R0_17 (net20[16], D, GSB);
rdp_io #(.l(5.1e-07), .w(1.5e-05), .m(1), .par1(1), .xf_subext(0))
(* integer passed_mfactor = "m"; *)
 R0_18 (net20[17], D, GSB);
rdp_io #(.l(5.1e-07), .w(1.5e-05), .m(1), .par1(1), .xf_subext(0))
(* integer passed_mfactor = "m"; *)
 R0_19 (net20[18], D, GSB);
rdp_io #(.l(5.1e-07), .w(1.5e-05), .m(1), .par1(1), .xf_subext(0))
(* integer passed_mfactor = "m"; *)
 R0_20 (net20[19], D, GSB);
rdp_io #(.l(5.1e-07), .w(1.5e-05), .m(1), .par1(1), .xf_subext(0))
(* integer passed_mfactor = "m"; *)
 R0_21 (net20[20], D, GSB);
rdp_io #(.l(5.1e-07), .w(1.5e-05), .m(1), .par1(1), .xf_subext(0))
(* integer passed_mfactor = "m"; *)
 R0_22 (net20[21], D, GSB);
rdp_io #(.l(5.1e-07), .w(1.5e-05), .m(1), .par1(1), .xf_subext(0))
(* integer passed_mfactor = "m"; *)
 R0_23 (net20[22], D, GSB);
rdp_io #(.l(5.1e-07), .w(1.5e-05), .m(1), .par1(1), .xf_subext(0))
(* integer passed_mfactor = "m"; *)
 R0_24 (net20[23], D, GSB);
rdp_io #(.l(5.1e-07), .w(1.5e-05), .m(1), .par1(1), .xf_subext(0))
(* integer passed_mfactor = "m"; *)
 R0_25 (net20[24], D, GSB);
rdp_io #(.l(5.1e-07), .w(1.5e-05), .m(1), .par1(1), .xf_subext(0))
(* integer passed_mfactor = "m"; *)
 R0_26 (net20[25], D, GSB);
rdp_io #(.l(5.1e-07), .w(1.5e-05), .m(1), .par1(1), .xf_subext(0))
(* integer passed_mfactor = "m"; *)
 R0_27 (net20[26], D, GSB);
rdp_io #(.l(5.1e-07), .w(1.5e-05), .m(1), .par1(1), .xf_subext(0))
(* integer passed_mfactor = "m"; *)
 R0_28 (net20[27], D, GSB);
rdp_io #(.l(5.1e-07), .w(1.5e-05), .m(1), .par1(1), .xf_subext(0))
(* integer passed_mfactor = "m"; *)
 R0_29 (net20[28], D, GSB);
rdp_io #(.l(5.1e-07), .w(1.5e-05), .m(1), .par1(1), .xf_subext(0))
(* integer passed_mfactor = "m"; *)
 R0_30 (net20[29], D, GSB);
rdp_io #(.l(5.1e-07), .w(1.5e-05), .m(1), .par1(1), .xf_subext(0))
(* integer passed_mfactor = "m"; *)
 R0_31 (net20[30], D, GSB);
rdp_io #(.l(5.1e-07), .w(1.5e-05), .m(1), .par1(1), .xf_subext(0))
(* integer passed_mfactor = "m"; *)
 R0_32 (net20[31], D, GSB);
rdp_io #(.l(5.1e-07), .w(1.5e-05), .m(1), .par1(1), .xf_subext(0))
(* integer passed_mfactor = "m"; *)
 R0_33 (net20[32], D, GSB);
rdp_io #(.l(5.1e-07), .w(1.5e-05), .m(1), .par1(1), .xf_subext(0))
(* integer passed_mfactor = "m"; *)
 R0_34 (net20[33], D, GSB);
rdp_io #(.l(5.1e-07), .w(1.5e-05), .m(1), .par1(1), .xf_subext(0))
(* integer passed_mfactor = "m"; *)
 R0_35 (net20[34], D, GSB);
rdp_io #(.l(5.1e-07), .w(1.5e-05), .m(1), .par1(1), .xf_subext(0))
(* integer passed_mfactor = "m"; *)
 R0_36 (net20[35], D, GSB);
rdp_io #(.l(5.1e-07), .w(1.5e-05), .m(1), .par1(1), .xf_subext(0))
(* integer passed_mfactor = "m"; *)
 R0_37 (net20[36], D, GSB);
rdp_io #(.l(5.1e-07), .w(1.5e-05), .m(1), .par1(1), .xf_subext(0))
(* integer passed_mfactor = "m"; *)
 R0_38 (net20[37], D, GSB);
rdp_io #(.l(5.1e-07), .w(1.5e-05), .m(1), .par1(1), .xf_subext(0))
(* integer passed_mfactor = "m"; *)
 R0_39 (net20[38], D, GSB);
rdp_io #(.l(5.1e-07), .w(1.5e-05), .m(1), .par1(1), .xf_subext(0))
(* integer passed_mfactor = "m"; *)
 R0_40 (net20[39], D, GSB);
rdp_io #(.l(5.1e-07), .w(1.5e-05), .m(1), .par1(1), .xf_subext(0))
(* integer passed_mfactor = "m"; *)
 R0_41 (net20[40], D, GSB);
rdp_io #(.l(5.1e-07), .w(1.5e-05), .m(1), .par1(1), .xf_subext(0))
(* integer passed_mfactor = "m"; *)
 R0_42 (net20[41], D, GSB);
rdp_io #(.l(5.1e-07), .w(1.5e-05), .m(1), .par1(1), .xf_subext(0))
(* integer passed_mfactor = "m"; *)
 R0_43 (net20[42], D, GSB);
rdp_io #(.l(5.1e-07), .w(1.5e-05), .m(1), .par1(1), .xf_subext(0))
(* integer passed_mfactor = "m"; *)
 R0_44 (net20[43], D, GSB);
rdp_io #(.l(5.1e-07), .w(1.5e-05), .m(1), .par1(1), .xf_subext(0))
(* integer passed_mfactor = "m"; *)
 R0_45 (net20[44], D, GSB);
rdp_io #(.l(5.1e-07), .w(1.5e-05), .m(1), .par1(1), .xf_subext(0))
(* integer passed_mfactor = "m"; *)
 R0_46 (net20[45], D, GSB);
rdp_io #(.l(5.1e-07), .w(1.5e-05), .m(1), .par1(1), .xf_subext(0))
(* integer passed_mfactor = "m"; *)
 R0_47 (net20[46], D, GSB);
rdp_io #(.l(5.1e-07), .w(1.5e-05), .m(1), .par1(1), .xf_subext(0))
(* integer passed_mfactor = "m"; *)
 R0_48 (net20[47], D, GSB);
rdp_io #(.l(5.1e-07), .w(1.5e-05), .m(1), .par1(1), .xf_subext(0))
(* integer passed_mfactor = "m"; *)
 R0_49 (net20[48], D, GSB);
rdp_io #(.l(5.1e-07), .w(1.5e-05), .m(1), .par1(1), .xf_subext(0))
(* integer passed_mfactor = "m"; *)
 R0_50 (net20[49], D, GSB);
dphnw #(.area(4.95062e-12), .perimeter(6.6e-07), .dbv(0), .m(1), .par1(1))
(* integer passed_mfactor = "m"; *)
 D0_1 (D, GSB);
dphnw #(.area(4.95062e-12), .perimeter(6.6e-07), .dbv(0), .m(1), .par1(1))
(* integer passed_mfactor = "m"; *)
 D0_2 (D, GSB);
dphnw #(.area(4.95062e-12), .perimeter(6.6e-07), .dbv(0), .m(1), .par1(1))
(* integer passed_mfactor = "m"; *)
 D0_3 (D, GSB);
dphnw #(.area(4.95062e-12), .perimeter(6.6e-07), .dbv(0), .m(1), .par1(1))
(* integer passed_mfactor = "m"; *)
 D0_4 (D, GSB);
dphnw #(.area(4.95062e-12), .perimeter(6.6e-07), .dbv(0), .m(1), .par1(1))
(* integer passed_mfactor = "m"; *)
 D0_5 (D, GSB);
dphnw #(.area(4.95062e-12), .perimeter(6.6e-07), .dbv(0), .m(1), .par1(1))
(* integer passed_mfactor = "m"; *)
 D0_6 (D, GSB);
dphnw #(.area(4.95062e-12), .perimeter(6.6e-07), .dbv(0), .m(1), .par1(1))
(* integer passed_mfactor = "m"; *)
 D0_7 (D, GSB);
dphnw #(.area(4.95062e-12), .perimeter(6.6e-07), .dbv(0), .m(1), .par1(1))
(* integer passed_mfactor = "m"; *)
 D0_8 (D, GSB);
dphnw #(.area(4.95062e-12), .perimeter(6.6e-07), .dbv(0), .m(1), .par1(1))
(* integer passed_mfactor = "m"; *)
 D0_9 (D, GSB);
dphnw #(.area(4.95062e-12), .perimeter(6.6e-07), .dbv(0), .m(1), .par1(1))
(* integer passed_mfactor = "m"; *)
 D0_10 (D, GSB);
dphnw #(.area(4.95062e-12), .perimeter(6.6e-07), .dbv(0), .m(1), .par1(1))
(* integer passed_mfactor = "m"; *)
 D0_11 (D, GSB);
dphnw #(.area(4.95062e-12), .perimeter(6.6e-07), .dbv(0), .m(1), .par1(1))
(* integer passed_mfactor = "m"; *)
 D0_12 (D, GSB);
dphnw #(.area(4.95062e-12), .perimeter(6.6e-07), .dbv(0), .m(1), .par1(1))
(* integer passed_mfactor = "m"; *)
 D0_13 (D, GSB);
dphnw #(.area(4.95062e-12), .perimeter(6.6e-07), .dbv(0), .m(1), .par1(1))
(* integer passed_mfactor = "m"; *)
 D0_14 (D, GSB);
dphnw #(.area(4.95062e-12), .perimeter(6.6e-07), .dbv(0), .m(1), .par1(1))
(* integer passed_mfactor = "m"; *)
 D0_15 (D, GSB);
dphnw #(.area(4.95062e-12), .perimeter(6.6e-07), .dbv(0), .m(1), .par1(1))
(* integer passed_mfactor = "m"; *)
 D0_16 (D, GSB);
dphnw #(.area(4.95062e-12), .perimeter(6.6e-07), .dbv(0), .m(1), .par1(1))
(* integer passed_mfactor = "m"; *)
 D0_17 (D, GSB);
dphnw #(.area(4.95062e-12), .perimeter(6.6e-07), .dbv(0), .m(1), .par1(1))
(* integer passed_mfactor = "m"; *)
 D0_18 (D, GSB);
dphnw #(.area(4.95062e-12), .perimeter(6.6e-07), .dbv(0), .m(1), .par1(1))
(* integer passed_mfactor = "m"; *)
 D0_19 (D, GSB);
dphnw #(.area(4.95062e-12), .perimeter(6.6e-07), .dbv(0), .m(1), .par1(1))
(* integer passed_mfactor = "m"; *)
 D0_20 (D, GSB);
dphnw #(.area(4.95062e-12), .perimeter(6.6e-07), .dbv(0), .m(1), .par1(1))
(* integer passed_mfactor = "m"; *)
 D0_21 (D, GSB);
dphnw #(.area(4.95062e-12), .perimeter(6.6e-07), .dbv(0), .m(1), .par1(1))
(* integer passed_mfactor = "m"; *)
 D0_22 (D, GSB);
dphnw #(.area(4.95062e-12), .perimeter(6.6e-07), .dbv(0), .m(1), .par1(1))
(* integer passed_mfactor = "m"; *)
 D0_23 (D, GSB);
dphnw #(.area(4.95062e-12), .perimeter(6.6e-07), .dbv(0), .m(1), .par1(1))
(* integer passed_mfactor = "m"; *)
 D0_24 (D, GSB);
dphnw #(.area(4.95062e-12), .perimeter(6.6e-07), .dbv(0), .m(1), .par1(1))
(* integer passed_mfactor = "m"; *)
 D0_25 (D, GSB);
dphnw #(.area(4.95062e-12), .perimeter(6.6e-07), .dbv(0), .m(1), .par1(1))
(* integer passed_mfactor = "m"; *)
 D0_26 (D, GSB);
dphnw #(.area(4.95062e-12), .perimeter(6.6e-07), .dbv(0), .m(1), .par1(1))
(* integer passed_mfactor = "m"; *)
 D0_27 (D, GSB);
dphnw #(.area(4.95062e-12), .perimeter(6.6e-07), .dbv(0), .m(1), .par1(1))
(* integer passed_mfactor = "m"; *)
 D0_28 (D, GSB);
dphnw #(.area(4.95062e-12), .perimeter(6.6e-07), .dbv(0), .m(1), .par1(1))
(* integer passed_mfactor = "m"; *)
 D0_29 (D, GSB);
dphnw #(.area(4.95062e-12), .perimeter(6.6e-07), .dbv(0), .m(1), .par1(1))
(* integer passed_mfactor = "m"; *)
 D0_30 (D, GSB);
dphnw #(.area(4.95062e-12), .perimeter(6.6e-07), .dbv(0), .m(1), .par1(1))
(* integer passed_mfactor = "m"; *)
 D0_31 (D, GSB);
dphnw #(.area(4.95062e-12), .perimeter(6.6e-07), .dbv(0), .m(1), .par1(1))
(* integer passed_mfactor = "m"; *)
 D0_32 (D, GSB);
dphnw #(.area(4.95062e-12), .perimeter(6.6e-07), .dbv(0), .m(1), .par1(1))
(* integer passed_mfactor = "m"; *)
 D0_33 (D, GSB);
dphnw #(.area(4.95062e-12), .perimeter(6.6e-07), .dbv(0), .m(1), .par1(1))
(* integer passed_mfactor = "m"; *)
 D0_34 (D, GSB);
dphnw #(.area(4.95062e-12), .perimeter(6.6e-07), .dbv(0), .m(1), .par1(1))
(* integer passed_mfactor = "m"; *)
 D0_35 (D, GSB);
dphnw #(.area(4.95062e-12), .perimeter(6.6e-07), .dbv(0), .m(1), .par1(1))
(* integer passed_mfactor = "m"; *)
 D0_36 (D, GSB);
dphnw #(.area(4.95062e-12), .perimeter(6.6e-07), .dbv(0), .m(1), .par1(1))
(* integer passed_mfactor = "m"; *)
 D0_37 (D, GSB);
dphnw #(.area(4.95062e-12), .perimeter(6.6e-07), .dbv(0), .m(1), .par1(1))
(* integer passed_mfactor = "m"; *)
 D0_38 (D, GSB);
dphnw #(.area(4.95062e-12), .perimeter(6.6e-07), .dbv(0), .m(1), .par1(1))
(* integer passed_mfactor = "m"; *)
 D0_39 (D, GSB);
dphnw #(.area(4.95062e-12), .perimeter(6.6e-07), .dbv(0), .m(1), .par1(1))
(* integer passed_mfactor = "m"; *)
 D0_40 (D, GSB);
dphnw #(.area(4.95062e-12), .perimeter(6.6e-07), .dbv(0), .m(1), .par1(1))
(* integer passed_mfactor = "m"; *)
 D0_41 (D, GSB);
dphnw #(.area(4.95062e-12), .perimeter(6.6e-07), .dbv(0), .m(1), .par1(1))
(* integer passed_mfactor = "m"; *)
 D0_42 (D, GSB);
dphnw #(.area(4.95062e-12), .perimeter(6.6e-07), .dbv(0), .m(1), .par1(1))
(* integer passed_mfactor = "m"; *)
 D0_43 (D, GSB);
dphnw #(.area(4.95062e-12), .perimeter(6.6e-07), .dbv(0), .m(1), .par1(1))
(* integer passed_mfactor = "m"; *)
 D0_44 (D, GSB);
dphnw #(.area(4.95062e-12), .perimeter(6.6e-07), .dbv(0), .m(1), .par1(1))
(* integer passed_mfactor = "m"; *)
 D0_45 (D, GSB);
dphnw #(.area(4.95062e-12), .perimeter(6.6e-07), .dbv(0), .m(1), .par1(1))
(* integer passed_mfactor = "m"; *)
 D0_46 (D, GSB);
dphnw #(.area(4.95062e-12), .perimeter(6.6e-07), .dbv(0), .m(1), .par1(1))
(* integer passed_mfactor = "m"; *)
 D0_47 (D, GSB);
dphnw #(.area(4.95062e-12), .perimeter(6.6e-07), .dbv(0), .m(1), .par1(1))
(* integer passed_mfactor = "m"; *)
 D0_48 (D, GSB);
dphnw #(.area(4.95062e-12), .perimeter(6.6e-07), .dbv(0), .m(1), .par1(1))
(* integer passed_mfactor = "m"; *)
 D0_49 (D, GSB);
dphnw #(.area(4.95062e-12), .perimeter(6.6e-07), .dbv(0), .m(1), .par1(1))
(* integer passed_mfactor = "m"; *)
 D0_50 (D, GSB);
ddnw #(.area(3.03711e-09), .perimeter(0.000284), .dbv(0), .m(1), .par1(1), .xf_subext(0))
(* integer passed_mfactor = "m"; *)
 D1 (Sub, GSB);

endmodule
// Library - HV_CELLS, Cell - ioh_c5pk, View - schematic
// LAST TIME SAVED: Feb 25 05:56:12 2015
// NETLIST TIME: Feb 12 01:23:42 2024

`worklib HV_CELLS
`view schematic

`timescale 1ns / 1ps
(* cds_ams_schematic *)

module ioh_c5pk (A_l, K_h, Sub);
inout  A_l, K_h, Sub;
wire net30;
wire net26;
wire net23;
wire net20;
ioh_pe3isabhv_1050gcr I5 (.Sub( Sub ), .SB( net30 ), .D( A_l ));
ioh_pmbsabhv_750 I3 (.Sub( Sub ), .D( net23 ), .GSB( net26 ));
ioh_pmbsabhv_750 I4 (.Sub( Sub ), .D( net30 ), .GSB( net23 ));
ioh_pmbsabhv_750 I2 (.Sub( Sub ), .D( net26 ), .GSB( net20 ));
ioh_pmbsabhv_750 I1 (.Sub( Sub ), .D( net20 ), .GSB( K_h ));

endmodule
// Library - HV_CELLS, Cell - HVD4SJD1R5PKFs, View - schematic
// LAST TIME SAVED: Feb 25 05:55:34 2015
// NETLIST TIME: Feb 12 01:23:42 2024

`worklib HV_CELLS
`view schematic

`timescale 1ns / 1ps
(* cds_ams_schematic *)

module HVD4SJD1R5PKFs (GNDO, IGND, PAD);
inout  GNDO, IGND, PAD;
wire Trig_0;
ioh_iscrd2_4x100 I10 (.Gp( Trig_0 ), .Sub( GNDO ), .A( PAD ), .Gn( PAD ), .K( IGND ));
ioh_dhpw_2x100_stack3 I9 (.A_l( IGND ), .Sub( GNDO ), .K_h( PAD ));
ioh_c5pk I11 (.Sub( GNDO ), .K_h( PAD ), .A_l( Trig_0 ));
rpp1s #(.l(1.6e-05), .w(0.0001), .m(1), .par1(1))
(* integer passed_mfactor = "m"; *)
 R4 (IGND, Trig_0);

endmodule
// Library - HV_CELLS, Cell - ioh_pmbsab_40_10, View - schematic
// LAST TIME SAVED: Feb 25 05:55:57 2015
// NETLIST TIME: Feb 12 01:23:42 2024

`worklib HV_CELLS
`view schematic

`timescale 1ns / 1ps
(* cds_ams_schematic *)

module ioh_pmbsab_40_10 (B, D, G, S);
inout  B, D, G, S;
pmb #(.w(4.012e-05), .l(1e-06), .as(1.92576e-11), .ad(1.92576e-11), .ps(8.12e-05), .pd(8.12e-05), .nrs(0.00672981), .nrd(0.00672981), .m((1)*(1)), .par1((1)*(1)))
(* integer passed_mfactor = "m"; *)
 MPX (D, G, S, B);

endmodule
// Library - HV_CELLS, Cell - ioh_pmbsabhv_2000, View - schematic
// LAST TIME SAVED: Feb 25 05:55:57 2015
// NETLIST TIME: Feb 12 01:23:42 2024

`worklib HV_CELLS
`view schematic

`timescale 1ns / 1ps
(* cds_ams_schematic *)

module ioh_pmbsabhv_2000 (D, GSB, Sub);
inout  D, GSB, Sub;
wire [0:49] net20;
ioh_pmbsab_40_10 MP_1 (.D( net20[0] ), .B( GSB ), .G( GSB ), .S( GSB ));
ioh_pmbsab_40_10 MP_2 (.D( net20[1] ), .B( GSB ), .G( GSB ), .S( GSB ));
ioh_pmbsab_40_10 MP_3 (.D( net20[2] ), .B( GSB ), .G( GSB ), .S( GSB ));
ioh_pmbsab_40_10 MP_4 (.D( net20[3] ), .B( GSB ), .G( GSB ), .S( GSB ));
ioh_pmbsab_40_10 MP_5 (.D( net20[4] ), .B( GSB ), .G( GSB ), .S( GSB ));
ioh_pmbsab_40_10 MP_6 (.D( net20[5] ), .B( GSB ), .G( GSB ), .S( GSB ));
ioh_pmbsab_40_10 MP_7 (.D( net20[6] ), .B( GSB ), .G( GSB ), .S( GSB ));
ioh_pmbsab_40_10 MP_8 (.D( net20[7] ), .B( GSB ), .G( GSB ), .S( GSB ));
ioh_pmbsab_40_10 MP_9 (.D( net20[8] ), .B( GSB ), .G( GSB ), .S( GSB ));
ioh_pmbsab_40_10 MP_10 (.D( net20[9] ), .B( GSB ), .G( GSB ), .S( GSB ));
ioh_pmbsab_40_10 MP_11 (.D( net20[10] ), .B( GSB ), .G( GSB ), .S( GSB ));
ioh_pmbsab_40_10 MP_12 (.D( net20[11] ), .B( GSB ), .G( GSB ), .S( GSB ));
ioh_pmbsab_40_10 MP_13 (.D( net20[12] ), .B( GSB ), .G( GSB ), .S( GSB ));
ioh_pmbsab_40_10 MP_14 (.D( net20[13] ), .B( GSB ), .G( GSB ), .S( GSB ));
ioh_pmbsab_40_10 MP_15 (.D( net20[14] ), .B( GSB ), .G( GSB ), .S( GSB ));
ioh_pmbsab_40_10 MP_16 (.D( net20[15] ), .B( GSB ), .G( GSB ), .S( GSB ));
ioh_pmbsab_40_10 MP_17 (.D( net20[16] ), .B( GSB ), .G( GSB ), .S( GSB ));
ioh_pmbsab_40_10 MP_18 (.D( net20[17] ), .B( GSB ), .G( GSB ), .S( GSB ));
ioh_pmbsab_40_10 MP_19 (.D( net20[18] ), .B( GSB ), .G( GSB ), .S( GSB ));
ioh_pmbsab_40_10 MP_20 (.D( net20[19] ), .B( GSB ), .G( GSB ), .S( GSB ));
ioh_pmbsab_40_10 MP_21 (.D( net20[20] ), .B( GSB ), .G( GSB ), .S( GSB ));
ioh_pmbsab_40_10 MP_22 (.D( net20[21] ), .B( GSB ), .G( GSB ), .S( GSB ));
ioh_pmbsab_40_10 MP_23 (.D( net20[22] ), .B( GSB ), .G( GSB ), .S( GSB ));
ioh_pmbsab_40_10 MP_24 (.D( net20[23] ), .B( GSB ), .G( GSB ), .S( GSB ));
ioh_pmbsab_40_10 MP_25 (.D( net20[24] ), .B( GSB ), .G( GSB ), .S( GSB ));
ioh_pmbsab_40_10 MP_26 (.D( net20[25] ), .B( GSB ), .G( GSB ), .S( GSB ));
ioh_pmbsab_40_10 MP_27 (.D( net20[26] ), .B( GSB ), .G( GSB ), .S( GSB ));
ioh_pmbsab_40_10 MP_28 (.D( net20[27] ), .B( GSB ), .G( GSB ), .S( GSB ));
ioh_pmbsab_40_10 MP_29 (.D( net20[28] ), .B( GSB ), .G( GSB ), .S( GSB ));
ioh_pmbsab_40_10 MP_30 (.D( net20[29] ), .B( GSB ), .G( GSB ), .S( GSB ));
ioh_pmbsab_40_10 MP_31 (.D( net20[30] ), .B( GSB ), .G( GSB ), .S( GSB ));
ioh_pmbsab_40_10 MP_32 (.D( net20[31] ), .B( GSB ), .G( GSB ), .S( GSB ));
ioh_pmbsab_40_10 MP_33 (.D( net20[32] ), .B( GSB ), .G( GSB ), .S( GSB ));
ioh_pmbsab_40_10 MP_34 (.D( net20[33] ), .B( GSB ), .G( GSB ), .S( GSB ));
ioh_pmbsab_40_10 MP_35 (.D( net20[34] ), .B( GSB ), .G( GSB ), .S( GSB ));
ioh_pmbsab_40_10 MP_36 (.D( net20[35] ), .B( GSB ), .G( GSB ), .S( GSB ));
ioh_pmbsab_40_10 MP_37 (.D( net20[36] ), .B( GSB ), .G( GSB ), .S( GSB ));
ioh_pmbsab_40_10 MP_38 (.D( net20[37] ), .B( GSB ), .G( GSB ), .S( GSB ));
ioh_pmbsab_40_10 MP_39 (.D( net20[38] ), .B( GSB ), .G( GSB ), .S( GSB ));
ioh_pmbsab_40_10 MP_40 (.D( net20[39] ), .B( GSB ), .G( GSB ), .S( GSB ));
ioh_pmbsab_40_10 MP_41 (.D( net20[40] ), .B( GSB ), .G( GSB ), .S( GSB ));
ioh_pmbsab_40_10 MP_42 (.D( net20[41] ), .B( GSB ), .G( GSB ), .S( GSB ));
ioh_pmbsab_40_10 MP_43 (.D( net20[42] ), .B( GSB ), .G( GSB ), .S( GSB ));
ioh_pmbsab_40_10 MP_44 (.D( net20[43] ), .B( GSB ), .G( GSB ), .S( GSB ));
ioh_pmbsab_40_10 MP_45 (.D( net20[44] ), .B( GSB ), .G( GSB ), .S( GSB ));
ioh_pmbsab_40_10 MP_46 (.D( net20[45] ), .B( GSB ), .G( GSB ), .S( GSB ));
ioh_pmbsab_40_10 MP_47 (.D( net20[46] ), .B( GSB ), .G( GSB ), .S( GSB ));
ioh_pmbsab_40_10 MP_48 (.D( net20[47] ), .B( GSB ), .G( GSB ), .S( GSB ));
ioh_pmbsab_40_10 MP_49 (.D( net20[48] ), .B( GSB ), .G( GSB ), .S( GSB ));
ioh_pmbsab_40_10 MP_50 (.D( net20[49] ), .B( GSB ), .G( GSB ), .S( GSB ));
rdp_io #(.l(5.1e-07), .w(4e-05), .m(1), .par1(1), .xf_subext(0))
(* integer passed_mfactor = "m"; *)
 R0_1 (net20[0], D, GSB);
rdp_io #(.l(5.1e-07), .w(4e-05), .m(1), .par1(1), .xf_subext(0))
(* integer passed_mfactor = "m"; *)
 R0_2 (net20[1], D, GSB);
rdp_io #(.l(5.1e-07), .w(4e-05), .m(1), .par1(1), .xf_subext(0))
(* integer passed_mfactor = "m"; *)
 R0_3 (net20[2], D, GSB);
rdp_io #(.l(5.1e-07), .w(4e-05), .m(1), .par1(1), .xf_subext(0))
(* integer passed_mfactor = "m"; *)
 R0_4 (net20[3], D, GSB);
rdp_io #(.l(5.1e-07), .w(4e-05), .m(1), .par1(1), .xf_subext(0))
(* integer passed_mfactor = "m"; *)
 R0_5 (net20[4], D, GSB);
rdp_io #(.l(5.1e-07), .w(4e-05), .m(1), .par1(1), .xf_subext(0))
(* integer passed_mfactor = "m"; *)
 R0_6 (net20[5], D, GSB);
rdp_io #(.l(5.1e-07), .w(4e-05), .m(1), .par1(1), .xf_subext(0))
(* integer passed_mfactor = "m"; *)
 R0_7 (net20[6], D, GSB);
rdp_io #(.l(5.1e-07), .w(4e-05), .m(1), .par1(1), .xf_subext(0))
(* integer passed_mfactor = "m"; *)
 R0_8 (net20[7], D, GSB);
rdp_io #(.l(5.1e-07), .w(4e-05), .m(1), .par1(1), .xf_subext(0))
(* integer passed_mfactor = "m"; *)
 R0_9 (net20[8], D, GSB);
rdp_io #(.l(5.1e-07), .w(4e-05), .m(1), .par1(1), .xf_subext(0))
(* integer passed_mfactor = "m"; *)
 R0_10 (net20[9], D, GSB);
rdp_io #(.l(5.1e-07), .w(4e-05), .m(1), .par1(1), .xf_subext(0))
(* integer passed_mfactor = "m"; *)
 R0_11 (net20[10], D, GSB);
rdp_io #(.l(5.1e-07), .w(4e-05), .m(1), .par1(1), .xf_subext(0))
(* integer passed_mfactor = "m"; *)
 R0_12 (net20[11], D, GSB);
rdp_io #(.l(5.1e-07), .w(4e-05), .m(1), .par1(1), .xf_subext(0))
(* integer passed_mfactor = "m"; *)
 R0_13 (net20[12], D, GSB);
rdp_io #(.l(5.1e-07), .w(4e-05), .m(1), .par1(1), .xf_subext(0))
(* integer passed_mfactor = "m"; *)
 R0_14 (net20[13], D, GSB);
rdp_io #(.l(5.1e-07), .w(4e-05), .m(1), .par1(1), .xf_subext(0))
(* integer passed_mfactor = "m"; *)
 R0_15 (net20[14], D, GSB);
rdp_io #(.l(5.1e-07), .w(4e-05), .m(1), .par1(1), .xf_subext(0))
(* integer passed_mfactor = "m"; *)
 R0_16 (net20[15], D, GSB);
rdp_io #(.l(5.1e-07), .w(4e-05), .m(1), .par1(1), .xf_subext(0))
(* integer passed_mfactor = "m"; *)
 R0_17 (net20[16], D, GSB);
rdp_io #(.l(5.1e-07), .w(4e-05), .m(1), .par1(1), .xf_subext(0))
(* integer passed_mfactor = "m"; *)
 R0_18 (net20[17], D, GSB);
rdp_io #(.l(5.1e-07), .w(4e-05), .m(1), .par1(1), .xf_subext(0))
(* integer passed_mfactor = "m"; *)
 R0_19 (net20[18], D, GSB);
rdp_io #(.l(5.1e-07), .w(4e-05), .m(1), .par1(1), .xf_subext(0))
(* integer passed_mfactor = "m"; *)
 R0_20 (net20[19], D, GSB);
rdp_io #(.l(5.1e-07), .w(4e-05), .m(1), .par1(1), .xf_subext(0))
(* integer passed_mfactor = "m"; *)
 R0_21 (net20[20], D, GSB);
rdp_io #(.l(5.1e-07), .w(4e-05), .m(1), .par1(1), .xf_subext(0))
(* integer passed_mfactor = "m"; *)
 R0_22 (net20[21], D, GSB);
rdp_io #(.l(5.1e-07), .w(4e-05), .m(1), .par1(1), .xf_subext(0))
(* integer passed_mfactor = "m"; *)
 R0_23 (net20[22], D, GSB);
rdp_io #(.l(5.1e-07), .w(4e-05), .m(1), .par1(1), .xf_subext(0))
(* integer passed_mfactor = "m"; *)
 R0_24 (net20[23], D, GSB);
rdp_io #(.l(5.1e-07), .w(4e-05), .m(1), .par1(1), .xf_subext(0))
(* integer passed_mfactor = "m"; *)
 R0_25 (net20[24], D, GSB);
rdp_io #(.l(5.1e-07), .w(4e-05), .m(1), .par1(1), .xf_subext(0))
(* integer passed_mfactor = "m"; *)
 R0_26 (net20[25], D, GSB);
rdp_io #(.l(5.1e-07), .w(4e-05), .m(1), .par1(1), .xf_subext(0))
(* integer passed_mfactor = "m"; *)
 R0_27 (net20[26], D, GSB);
rdp_io #(.l(5.1e-07), .w(4e-05), .m(1), .par1(1), .xf_subext(0))
(* integer passed_mfactor = "m"; *)
 R0_28 (net20[27], D, GSB);
rdp_io #(.l(5.1e-07), .w(4e-05), .m(1), .par1(1), .xf_subext(0))
(* integer passed_mfactor = "m"; *)
 R0_29 (net20[28], D, GSB);
rdp_io #(.l(5.1e-07), .w(4e-05), .m(1), .par1(1), .xf_subext(0))
(* integer passed_mfactor = "m"; *)
 R0_30 (net20[29], D, GSB);
rdp_io #(.l(5.1e-07), .w(4e-05), .m(1), .par1(1), .xf_subext(0))
(* integer passed_mfactor = "m"; *)
 R0_31 (net20[30], D, GSB);
rdp_io #(.l(5.1e-07), .w(4e-05), .m(1), .par1(1), .xf_subext(0))
(* integer passed_mfactor = "m"; *)
 R0_32 (net20[31], D, GSB);
rdp_io #(.l(5.1e-07), .w(4e-05), .m(1), .par1(1), .xf_subext(0))
(* integer passed_mfactor = "m"; *)
 R0_33 (net20[32], D, GSB);
rdp_io #(.l(5.1e-07), .w(4e-05), .m(1), .par1(1), .xf_subext(0))
(* integer passed_mfactor = "m"; *)
 R0_34 (net20[33], D, GSB);
rdp_io #(.l(5.1e-07), .w(4e-05), .m(1), .par1(1), .xf_subext(0))
(* integer passed_mfactor = "m"; *)
 R0_35 (net20[34], D, GSB);
rdp_io #(.l(5.1e-07), .w(4e-05), .m(1), .par1(1), .xf_subext(0))
(* integer passed_mfactor = "m"; *)
 R0_36 (net20[35], D, GSB);
rdp_io #(.l(5.1e-07), .w(4e-05), .m(1), .par1(1), .xf_subext(0))
(* integer passed_mfactor = "m"; *)
 R0_37 (net20[36], D, GSB);
rdp_io #(.l(5.1e-07), .w(4e-05), .m(1), .par1(1), .xf_subext(0))
(* integer passed_mfactor = "m"; *)
 R0_38 (net20[37], D, GSB);
rdp_io #(.l(5.1e-07), .w(4e-05), .m(1), .par1(1), .xf_subext(0))
(* integer passed_mfactor = "m"; *)
 R0_39 (net20[38], D, GSB);
rdp_io #(.l(5.1e-07), .w(4e-05), .m(1), .par1(1), .xf_subext(0))
(* integer passed_mfactor = "m"; *)
 R0_40 (net20[39], D, GSB);
rdp_io #(.l(5.1e-07), .w(4e-05), .m(1), .par1(1), .xf_subext(0))
(* integer passed_mfactor = "m"; *)
 R0_41 (net20[40], D, GSB);
rdp_io #(.l(5.1e-07), .w(4e-05), .m(1), .par1(1), .xf_subext(0))
(* integer passed_mfactor = "m"; *)
 R0_42 (net20[41], D, GSB);
rdp_io #(.l(5.1e-07), .w(4e-05), .m(1), .par1(1), .xf_subext(0))
(* integer passed_mfactor = "m"; *)
 R0_43 (net20[42], D, GSB);
rdp_io #(.l(5.1e-07), .w(4e-05), .m(1), .par1(1), .xf_subext(0))
(* integer passed_mfactor = "m"; *)
 R0_44 (net20[43], D, GSB);
rdp_io #(.l(5.1e-07), .w(4e-05), .m(1), .par1(1), .xf_subext(0))
(* integer passed_mfactor = "m"; *)
 R0_45 (net20[44], D, GSB);
rdp_io #(.l(5.1e-07), .w(4e-05), .m(1), .par1(1), .xf_subext(0))
(* integer passed_mfactor = "m"; *)
 R0_46 (net20[45], D, GSB);
rdp_io #(.l(5.1e-07), .w(4e-05), .m(1), .par1(1), .xf_subext(0))
(* integer passed_mfactor = "m"; *)
 R0_47 (net20[46], D, GSB);
rdp_io #(.l(5.1e-07), .w(4e-05), .m(1), .par1(1), .xf_subext(0))
(* integer passed_mfactor = "m"; *)
 R0_48 (net20[47], D, GSB);
rdp_io #(.l(5.1e-07), .w(4e-05), .m(1), .par1(1), .xf_subext(0))
(* integer passed_mfactor = "m"; *)
 R0_49 (net20[48], D, GSB);
rdp_io #(.l(5.1e-07), .w(4e-05), .m(1), .par1(1), .xf_subext(0))
(* integer passed_mfactor = "m"; *)
 R0_50 (net20[49], D, GSB);
dphnw #(.area(1.32132e-11), .perimeter(6.6e-07), .dbv(0), .m(1), .par1(1))
(* integer passed_mfactor = "m"; *)
 D0_1 (D, GSB);
dphnw #(.area(1.32132e-11), .perimeter(6.6e-07), .dbv(0), .m(1), .par1(1))
(* integer passed_mfactor = "m"; *)
 D0_2 (D, GSB);
dphnw #(.area(1.32132e-11), .perimeter(6.6e-07), .dbv(0), .m(1), .par1(1))
(* integer passed_mfactor = "m"; *)
 D0_3 (D, GSB);
dphnw #(.area(1.32132e-11), .perimeter(6.6e-07), .dbv(0), .m(1), .par1(1))
(* integer passed_mfactor = "m"; *)
 D0_4 (D, GSB);
dphnw #(.area(1.32132e-11), .perimeter(6.6e-07), .dbv(0), .m(1), .par1(1))
(* integer passed_mfactor = "m"; *)
 D0_5 (D, GSB);
dphnw #(.area(1.32132e-11), .perimeter(6.6e-07), .dbv(0), .m(1), .par1(1))
(* integer passed_mfactor = "m"; *)
 D0_6 (D, GSB);
dphnw #(.area(1.32132e-11), .perimeter(6.6e-07), .dbv(0), .m(1), .par1(1))
(* integer passed_mfactor = "m"; *)
 D0_7 (D, GSB);
dphnw #(.area(1.32132e-11), .perimeter(6.6e-07), .dbv(0), .m(1), .par1(1))
(* integer passed_mfactor = "m"; *)
 D0_8 (D, GSB);
dphnw #(.area(1.32132e-11), .perimeter(6.6e-07), .dbv(0), .m(1), .par1(1))
(* integer passed_mfactor = "m"; *)
 D0_9 (D, GSB);
dphnw #(.area(1.32132e-11), .perimeter(6.6e-07), .dbv(0), .m(1), .par1(1))
(* integer passed_mfactor = "m"; *)
 D0_10 (D, GSB);
dphnw #(.area(1.32132e-11), .perimeter(6.6e-07), .dbv(0), .m(1), .par1(1))
(* integer passed_mfactor = "m"; *)
 D0_11 (D, GSB);
dphnw #(.area(1.32132e-11), .perimeter(6.6e-07), .dbv(0), .m(1), .par1(1))
(* integer passed_mfactor = "m"; *)
 D0_12 (D, GSB);
dphnw #(.area(1.32132e-11), .perimeter(6.6e-07), .dbv(0), .m(1), .par1(1))
(* integer passed_mfactor = "m"; *)
 D0_13 (D, GSB);
dphnw #(.area(1.32132e-11), .perimeter(6.6e-07), .dbv(0), .m(1), .par1(1))
(* integer passed_mfactor = "m"; *)
 D0_14 (D, GSB);
dphnw #(.area(1.32132e-11), .perimeter(6.6e-07), .dbv(0), .m(1), .par1(1))
(* integer passed_mfactor = "m"; *)
 D0_15 (D, GSB);
dphnw #(.area(1.32132e-11), .perimeter(6.6e-07), .dbv(0), .m(1), .par1(1))
(* integer passed_mfactor = "m"; *)
 D0_16 (D, GSB);
dphnw #(.area(1.32132e-11), .perimeter(6.6e-07), .dbv(0), .m(1), .par1(1))
(* integer passed_mfactor = "m"; *)
 D0_17 (D, GSB);
dphnw #(.area(1.32132e-11), .perimeter(6.6e-07), .dbv(0), .m(1), .par1(1))
(* integer passed_mfactor = "m"; *)
 D0_18 (D, GSB);
dphnw #(.area(1.32132e-11), .perimeter(6.6e-07), .dbv(0), .m(1), .par1(1))
(* integer passed_mfactor = "m"; *)
 D0_19 (D, GSB);
dphnw #(.area(1.32132e-11), .perimeter(6.6e-07), .dbv(0), .m(1), .par1(1))
(* integer passed_mfactor = "m"; *)
 D0_20 (D, GSB);
dphnw #(.area(1.32132e-11), .perimeter(6.6e-07), .dbv(0), .m(1), .par1(1))
(* integer passed_mfactor = "m"; *)
 D0_21 (D, GSB);
dphnw #(.area(1.32132e-11), .perimeter(6.6e-07), .dbv(0), .m(1), .par1(1))
(* integer passed_mfactor = "m"; *)
 D0_22 (D, GSB);
dphnw #(.area(1.32132e-11), .perimeter(6.6e-07), .dbv(0), .m(1), .par1(1))
(* integer passed_mfactor = "m"; *)
 D0_23 (D, GSB);
dphnw #(.area(1.32132e-11), .perimeter(6.6e-07), .dbv(0), .m(1), .par1(1))
(* integer passed_mfactor = "m"; *)
 D0_24 (D, GSB);
dphnw #(.area(1.32132e-11), .perimeter(6.6e-07), .dbv(0), .m(1), .par1(1))
(* integer passed_mfactor = "m"; *)
 D0_25 (D, GSB);
dphnw #(.area(1.32132e-11), .perimeter(6.6e-07), .dbv(0), .m(1), .par1(1))
(* integer passed_mfactor = "m"; *)
 D0_26 (D, GSB);
dphnw #(.area(1.32132e-11), .perimeter(6.6e-07), .dbv(0), .m(1), .par1(1))
(* integer passed_mfactor = "m"; *)
 D0_27 (D, GSB);
dphnw #(.area(1.32132e-11), .perimeter(6.6e-07), .dbv(0), .m(1), .par1(1))
(* integer passed_mfactor = "m"; *)
 D0_28 (D, GSB);
dphnw #(.area(1.32132e-11), .perimeter(6.6e-07), .dbv(0), .m(1), .par1(1))
(* integer passed_mfactor = "m"; *)
 D0_29 (D, GSB);
dphnw #(.area(1.32132e-11), .perimeter(6.6e-07), .dbv(0), .m(1), .par1(1))
(* integer passed_mfactor = "m"; *)
 D0_30 (D, GSB);
dphnw #(.area(1.32132e-11), .perimeter(6.6e-07), .dbv(0), .m(1), .par1(1))
(* integer passed_mfactor = "m"; *)
 D0_31 (D, GSB);
dphnw #(.area(1.32132e-11), .perimeter(6.6e-07), .dbv(0), .m(1), .par1(1))
(* integer passed_mfactor = "m"; *)
 D0_32 (D, GSB);
dphnw #(.area(1.32132e-11), .perimeter(6.6e-07), .dbv(0), .m(1), .par1(1))
(* integer passed_mfactor = "m"; *)
 D0_33 (D, GSB);
dphnw #(.area(1.32132e-11), .perimeter(6.6e-07), .dbv(0), .m(1), .par1(1))
(* integer passed_mfactor = "m"; *)
 D0_34 (D, GSB);
dphnw #(.area(1.32132e-11), .perimeter(6.6e-07), .dbv(0), .m(1), .par1(1))
(* integer passed_mfactor = "m"; *)
 D0_35 (D, GSB);
dphnw #(.area(1.32132e-11), .perimeter(6.6e-07), .dbv(0), .m(1), .par1(1))
(* integer passed_mfactor = "m"; *)
 D0_36 (D, GSB);
dphnw #(.area(1.32132e-11), .perimeter(6.6e-07), .dbv(0), .m(1), .par1(1))
(* integer passed_mfactor = "m"; *)
 D0_37 (D, GSB);
dphnw #(.area(1.32132e-11), .perimeter(6.6e-07), .dbv(0), .m(1), .par1(1))
(* integer passed_mfactor = "m"; *)
 D0_38 (D, GSB);
dphnw #(.area(1.32132e-11), .perimeter(6.6e-07), .dbv(0), .m(1), .par1(1))
(* integer passed_mfactor = "m"; *)
 D0_39 (D, GSB);
dphnw #(.area(1.32132e-11), .perimeter(6.6e-07), .dbv(0), .m(1), .par1(1))
(* integer passed_mfactor = "m"; *)
 D0_40 (D, GSB);
dphnw #(.area(1.32132e-11), .perimeter(6.6e-07), .dbv(0), .m(1), .par1(1))
(* integer passed_mfactor = "m"; *)
 D0_41 (D, GSB);
dphnw #(.area(1.32132e-11), .perimeter(6.6e-07), .dbv(0), .m(1), .par1(1))
(* integer passed_mfactor = "m"; *)
 D0_42 (D, GSB);
dphnw #(.area(1.32132e-11), .perimeter(6.6e-07), .dbv(0), .m(1), .par1(1))
(* integer passed_mfactor = "m"; *)
 D0_43 (D, GSB);
dphnw #(.area(1.32132e-11), .perimeter(6.6e-07), .dbv(0), .m(1), .par1(1))
(* integer passed_mfactor = "m"; *)
 D0_44 (D, GSB);
dphnw #(.area(1.32132e-11), .perimeter(6.6e-07), .dbv(0), .m(1), .par1(1))
(* integer passed_mfactor = "m"; *)
 D0_45 (D, GSB);
dphnw #(.area(1.32132e-11), .perimeter(6.6e-07), .dbv(0), .m(1), .par1(1))
(* integer passed_mfactor = "m"; *)
 D0_46 (D, GSB);
dphnw #(.area(1.32132e-11), .perimeter(6.6e-07), .dbv(0), .m(1), .par1(1))
(* integer passed_mfactor = "m"; *)
 D0_47 (D, GSB);
dphnw #(.area(1.32132e-11), .perimeter(6.6e-07), .dbv(0), .m(1), .par1(1))
(* integer passed_mfactor = "m"; *)
 D0_48 (D, GSB);
dphnw #(.area(1.32132e-11), .perimeter(6.6e-07), .dbv(0), .m(1), .par1(1))
(* integer passed_mfactor = "m"; *)
 D0_49 (D, GSB);
dphnw #(.area(1.32132e-11), .perimeter(6.6e-07), .dbv(0), .m(1), .par1(1))
(* integer passed_mfactor = "m"; *)
 D0_50 (D, GSB);
ddnw #(.area(5.93593e-09), .perimeter(0.0003342), .dbv(0), .m(1), .par1(1), .xf_subext(0))
(* integer passed_mfactor = "m"; *)
 D1 (Sub, GSB);

endmodule
// Library - HV_CELLS, Cell - ioh_pe3isab_40_04, View - schematic
// LAST TIME SAVED: Feb 25 05:55:55 2015
// NETLIST TIME: Feb 12 01:23:42 2024

`worklib HV_CELLS
`view schematic

`timescale 1ns / 1ps
(* cds_ams_schematic *)

module ioh_pe3isab_40_04 (B, D, G, S);
inout  B, D, G, S;
pe3i #(.w(4e-05), .l(4e-07), .as(1.92e-11), .ad(1.92e-11), .ps(8.096e-05), .pd(8.096e-05), .nrs(0.00675), .nrd(0.00675), .m((1)*(1)), .par1((1)*(1)))
(* integer passed_mfactor = "m"; *)
 MPX (net17, G, S, B);
rdp3 #(.l(4.3e-07), .w(4e-05), .m(1), .par1(1))
(* integer passed_mfactor = "m"; *)
 R0 (net17, D, B);

endmodule
// Library - HV_CELLS, Cell - ioh_pe3isabhv_2800gcr, View - schematic
// LAST TIME SAVED: Feb 25 05:55:56 2015
// NETLIST TIME: Feb 12 01:23:42 2024

`worklib HV_CELLS
`view schematic

`timescale 1ns / 1ps
(* cds_ams_schematic *)

module ioh_pe3isabhv_2800gcr (D, SB, Sub);
inout  D, SB, Sub;
wire net20;
ioh_pe3isab_40_04 MP_1 (.D( D ), .B( SB ), .G( net20 ), .S( SB ));
ioh_pe3isab_40_04 MP_2 (.D( D ), .B( SB ), .G( net20 ), .S( SB ));
ioh_pe3isab_40_04 MP_3 (.D( D ), .B( SB ), .G( net20 ), .S( SB ));
ioh_pe3isab_40_04 MP_4 (.D( D ), .B( SB ), .G( net20 ), .S( SB ));
ioh_pe3isab_40_04 MP_5 (.D( D ), .B( SB ), .G( net20 ), .S( SB ));
ioh_pe3isab_40_04 MP_6 (.D( D ), .B( SB ), .G( net20 ), .S( SB ));
ioh_pe3isab_40_04 MP_7 (.D( D ), .B( SB ), .G( net20 ), .S( SB ));
ioh_pe3isab_40_04 MP_8 (.D( D ), .B( SB ), .G( net20 ), .S( SB ));
ioh_pe3isab_40_04 MP_9 (.D( D ), .B( SB ), .G( net20 ), .S( SB ));
ioh_pe3isab_40_04 MP_10 (.D( D ), .B( SB ), .G( net20 ), .S( SB ));
ioh_pe3isab_40_04 MP_11 (.D( D ), .B( SB ), .G( net20 ), .S( SB ));
ioh_pe3isab_40_04 MP_12 (.D( D ), .B( SB ), .G( net20 ), .S( SB ));
ioh_pe3isab_40_04 MP_13 (.D( D ), .B( SB ), .G( net20 ), .S( SB ));
ioh_pe3isab_40_04 MP_14 (.D( D ), .B( SB ), .G( net20 ), .S( SB ));
ioh_pe3isab_40_04 MP_15 (.D( D ), .B( SB ), .G( net20 ), .S( SB ));
ioh_pe3isab_40_04 MP_16 (.D( D ), .B( SB ), .G( net20 ), .S( SB ));
ioh_pe3isab_40_04 MP_17 (.D( D ), .B( SB ), .G( net20 ), .S( SB ));
ioh_pe3isab_40_04 MP_18 (.D( D ), .B( SB ), .G( net20 ), .S( SB ));
ioh_pe3isab_40_04 MP_19 (.D( D ), .B( SB ), .G( net20 ), .S( SB ));
ioh_pe3isab_40_04 MP_20 (.D( D ), .B( SB ), .G( net20 ), .S( SB ));
ioh_pe3isab_40_04 MP_21 (.D( D ), .B( SB ), .G( net20 ), .S( SB ));
ioh_pe3isab_40_04 MP_22 (.D( D ), .B( SB ), .G( net20 ), .S( SB ));
ioh_pe3isab_40_04 MP_23 (.D( D ), .B( SB ), .G( net20 ), .S( SB ));
ioh_pe3isab_40_04 MP_24 (.D( D ), .B( SB ), .G( net20 ), .S( SB ));
ioh_pe3isab_40_04 MP_25 (.D( D ), .B( SB ), .G( net20 ), .S( SB ));
ioh_pe3isab_40_04 MP_26 (.D( D ), .B( SB ), .G( net20 ), .S( SB ));
ioh_pe3isab_40_04 MP_27 (.D( D ), .B( SB ), .G( net20 ), .S( SB ));
ioh_pe3isab_40_04 MP_28 (.D( D ), .B( SB ), .G( net20 ), .S( SB ));
ioh_pe3isab_40_04 MP_29 (.D( D ), .B( SB ), .G( net20 ), .S( SB ));
ioh_pe3isab_40_04 MP_30 (.D( D ), .B( SB ), .G( net20 ), .S( SB ));
ioh_pe3isab_40_04 MP_31 (.D( D ), .B( SB ), .G( net20 ), .S( SB ));
ioh_pe3isab_40_04 MP_32 (.D( D ), .B( SB ), .G( net20 ), .S( SB ));
ioh_pe3isab_40_04 MP_33 (.D( D ), .B( SB ), .G( net20 ), .S( SB ));
ioh_pe3isab_40_04 MP_34 (.D( D ), .B( SB ), .G( net20 ), .S( SB ));
ioh_pe3isab_40_04 MP_35 (.D( D ), .B( SB ), .G( net20 ), .S( SB ));
ioh_pe3isab_40_04 MP_36 (.D( D ), .B( SB ), .G( net20 ), .S( SB ));
ioh_pe3isab_40_04 MP_37 (.D( D ), .B( SB ), .G( net20 ), .S( SB ));
ioh_pe3isab_40_04 MP_38 (.D( D ), .B( SB ), .G( net20 ), .S( SB ));
ioh_pe3isab_40_04 MP_39 (.D( D ), .B( SB ), .G( net20 ), .S( SB ));
ioh_pe3isab_40_04 MP_40 (.D( D ), .B( SB ), .G( net20 ), .S( SB ));
ioh_pe3isab_40_04 MP_41 (.D( D ), .B( SB ), .G( net20 ), .S( SB ));
ioh_pe3isab_40_04 MP_42 (.D( D ), .B( SB ), .G( net20 ), .S( SB ));
ioh_pe3isab_40_04 MP_43 (.D( D ), .B( SB ), .G( net20 ), .S( SB ));
ioh_pe3isab_40_04 MP_44 (.D( D ), .B( SB ), .G( net20 ), .S( SB ));
ioh_pe3isab_40_04 MP_45 (.D( D ), .B( SB ), .G( net20 ), .S( SB ));
ioh_pe3isab_40_04 MP_46 (.D( D ), .B( SB ), .G( net20 ), .S( SB ));
ioh_pe3isab_40_04 MP_47 (.D( D ), .B( SB ), .G( net20 ), .S( SB ));
ioh_pe3isab_40_04 MP_48 (.D( D ), .B( SB ), .G( net20 ), .S( SB ));
ioh_pe3isab_40_04 MP_49 (.D( D ), .B( SB ), .G( net20 ), .S( SB ));
ioh_pe3isab_40_04 MP_50 (.D( D ), .B( SB ), .G( net20 ), .S( SB ));
ioh_pe3isab_40_04 MP_51 (.D( D ), .B( SB ), .G( net20 ), .S( SB ));
ioh_pe3isab_40_04 MP_52 (.D( D ), .B( SB ), .G( net20 ), .S( SB ));
ioh_pe3isab_40_04 MP_53 (.D( D ), .B( SB ), .G( net20 ), .S( SB ));
ioh_pe3isab_40_04 MP_54 (.D( D ), .B( SB ), .G( net20 ), .S( SB ));
ioh_pe3isab_40_04 MP_55 (.D( D ), .B( SB ), .G( net20 ), .S( SB ));
ioh_pe3isab_40_04 MP_56 (.D( D ), .B( SB ), .G( net20 ), .S( SB ));
ioh_pe3isab_40_04 MP_57 (.D( D ), .B( SB ), .G( net20 ), .S( SB ));
ioh_pe3isab_40_04 MP_58 (.D( D ), .B( SB ), .G( net20 ), .S( SB ));
ioh_pe3isab_40_04 MP_59 (.D( D ), .B( SB ), .G( net20 ), .S( SB ));
ioh_pe3isab_40_04 MP_60 (.D( D ), .B( SB ), .G( net20 ), .S( SB ));
ioh_pe3isab_40_04 MP_61 (.D( D ), .B( SB ), .G( net20 ), .S( SB ));
ioh_pe3isab_40_04 MP_62 (.D( D ), .B( SB ), .G( net20 ), .S( SB ));
ioh_pe3isab_40_04 MP_63 (.D( D ), .B( SB ), .G( net20 ), .S( SB ));
ioh_pe3isab_40_04 MP_64 (.D( D ), .B( SB ), .G( net20 ), .S( SB ));
ioh_pe3isab_40_04 MP_65 (.D( D ), .B( SB ), .G( net20 ), .S( SB ));
ioh_pe3isab_40_04 MP_66 (.D( D ), .B( SB ), .G( net20 ), .S( SB ));
ioh_pe3isab_40_04 MP_67 (.D( D ), .B( SB ), .G( net20 ), .S( SB ));
ioh_pe3isab_40_04 MP_68 (.D( D ), .B( SB ), .G( net20 ), .S( SB ));
ioh_pe3isab_40_04 MP_69 (.D( D ), .B( SB ), .G( net20 ), .S( SB ));
ioh_pe3isab_40_04 MP_70 (.D( D ), .B( SB ), .G( net20 ), .S( SB ));
dp3 #(.area(2.64196e-11), .perimeter(1.32e-06), .dbv(0), .m(1), .par1(1))
(* integer passed_mfactor = "m"; *)
 MD_1 (D, SB);
dp3 #(.area(2.64196e-11), .perimeter(1.32e-06), .dbv(0), .m(1), .par1(1))
(* integer passed_mfactor = "m"; *)
 MD_2 (D, SB);
dp3 #(.area(2.64196e-11), .perimeter(1.32e-06), .dbv(0), .m(1), .par1(1))
(* integer passed_mfactor = "m"; *)
 MD_3 (D, SB);
dp3 #(.area(2.64196e-11), .perimeter(1.32e-06), .dbv(0), .m(1), .par1(1))
(* integer passed_mfactor = "m"; *)
 MD_4 (D, SB);
dp3 #(.area(2.64196e-11), .perimeter(1.32e-06), .dbv(0), .m(1), .par1(1))
(* integer passed_mfactor = "m"; *)
 MD_5 (D, SB);
dp3 #(.area(2.64196e-11), .perimeter(1.32e-06), .dbv(0), .m(1), .par1(1))
(* integer passed_mfactor = "m"; *)
 MD_6 (D, SB);
dp3 #(.area(2.64196e-11), .perimeter(1.32e-06), .dbv(0), .m(1), .par1(1))
(* integer passed_mfactor = "m"; *)
 MD_7 (D, SB);
dp3 #(.area(2.64196e-11), .perimeter(1.32e-06), .dbv(0), .m(1), .par1(1))
(* integer passed_mfactor = "m"; *)
 MD_8 (D, SB);
dp3 #(.area(2.64196e-11), .perimeter(1.32e-06), .dbv(0), .m(1), .par1(1))
(* integer passed_mfactor = "m"; *)
 MD_9 (D, SB);
dp3 #(.area(2.64196e-11), .perimeter(1.32e-06), .dbv(0), .m(1), .par1(1))
(* integer passed_mfactor = "m"; *)
 MD_10 (D, SB);
dp3 #(.area(2.64196e-11), .perimeter(1.32e-06), .dbv(0), .m(1), .par1(1))
(* integer passed_mfactor = "m"; *)
 MD_11 (D, SB);
dp3 #(.area(2.64196e-11), .perimeter(1.32e-06), .dbv(0), .m(1), .par1(1))
(* integer passed_mfactor = "m"; *)
 MD_12 (D, SB);
dp3 #(.area(2.64196e-11), .perimeter(1.32e-06), .dbv(0), .m(1), .par1(1))
(* integer passed_mfactor = "m"; *)
 MD_13 (D, SB);
dp3 #(.area(2.64196e-11), .perimeter(1.32e-06), .dbv(0), .m(1), .par1(1))
(* integer passed_mfactor = "m"; *)
 MD_14 (D, SB);
dp3 #(.area(2.64196e-11), .perimeter(1.32e-06), .dbv(0), .m(1), .par1(1))
(* integer passed_mfactor = "m"; *)
 MD_15 (D, SB);
dp3 #(.area(2.64196e-11), .perimeter(1.32e-06), .dbv(0), .m(1), .par1(1))
(* integer passed_mfactor = "m"; *)
 MD_16 (D, SB);
dp3 #(.area(2.64196e-11), .perimeter(1.32e-06), .dbv(0), .m(1), .par1(1))
(* integer passed_mfactor = "m"; *)
 MD_17 (D, SB);
dp3 #(.area(2.64196e-11), .perimeter(1.32e-06), .dbv(0), .m(1), .par1(1))
(* integer passed_mfactor = "m"; *)
 MD_18 (D, SB);
dp3 #(.area(2.64196e-11), .perimeter(1.32e-06), .dbv(0), .m(1), .par1(1))
(* integer passed_mfactor = "m"; *)
 MD_19 (D, SB);
dp3 #(.area(2.64196e-11), .perimeter(1.32e-06), .dbv(0), .m(1), .par1(1))
(* integer passed_mfactor = "m"; *)
 MD_20 (D, SB);
dp3 #(.area(2.64196e-11), .perimeter(1.32e-06), .dbv(0), .m(1), .par1(1))
(* integer passed_mfactor = "m"; *)
 MD_21 (D, SB);
dp3 #(.area(2.64196e-11), .perimeter(1.32e-06), .dbv(0), .m(1), .par1(1))
(* integer passed_mfactor = "m"; *)
 MD_22 (D, SB);
dp3 #(.area(2.64196e-11), .perimeter(1.32e-06), .dbv(0), .m(1), .par1(1))
(* integer passed_mfactor = "m"; *)
 MD_23 (D, SB);
dp3 #(.area(2.64196e-11), .perimeter(1.32e-06), .dbv(0), .m(1), .par1(1))
(* integer passed_mfactor = "m"; *)
 MD_24 (D, SB);
dp3 #(.area(2.64196e-11), .perimeter(1.32e-06), .dbv(0), .m(1), .par1(1))
(* integer passed_mfactor = "m"; *)
 MD_25 (D, SB);
dp3 #(.area(2.64196e-11), .perimeter(1.32e-06), .dbv(0), .m(1), .par1(1))
(* integer passed_mfactor = "m"; *)
 MD_26 (D, SB);
dp3 #(.area(2.64196e-11), .perimeter(1.32e-06), .dbv(0), .m(1), .par1(1))
(* integer passed_mfactor = "m"; *)
 MD_27 (D, SB);
dp3 #(.area(2.64196e-11), .perimeter(1.32e-06), .dbv(0), .m(1), .par1(1))
(* integer passed_mfactor = "m"; *)
 MD_28 (D, SB);
dp3 #(.area(2.64196e-11), .perimeter(1.32e-06), .dbv(0), .m(1), .par1(1))
(* integer passed_mfactor = "m"; *)
 MD_29 (D, SB);
dp3 #(.area(2.64196e-11), .perimeter(1.32e-06), .dbv(0), .m(1), .par1(1))
(* integer passed_mfactor = "m"; *)
 MD_30 (D, SB);
dp3 #(.area(2.64196e-11), .perimeter(1.32e-06), .dbv(0), .m(1), .par1(1))
(* integer passed_mfactor = "m"; *)
 MD_31 (D, SB);
dp3 #(.area(2.64196e-11), .perimeter(1.32e-06), .dbv(0), .m(1), .par1(1))
(* integer passed_mfactor = "m"; *)
 MD_32 (D, SB);
dp3 #(.area(2.64196e-11), .perimeter(1.32e-06), .dbv(0), .m(1), .par1(1))
(* integer passed_mfactor = "m"; *)
 MD_33 (D, SB);
dp3 #(.area(2.64196e-11), .perimeter(1.32e-06), .dbv(0), .m(1), .par1(1))
(* integer passed_mfactor = "m"; *)
 MD_34 (D, SB);
dp3 #(.area(2.64196e-11), .perimeter(1.32e-06), .dbv(0), .m(1), .par1(1))
(* integer passed_mfactor = "m"; *)
 MD_35 (D, SB);
ddnw #(.area(5.99695e-09), .perimeter(0.0003352), .dbv(0), .m(1), .par1(1), .xf_subext(0))
(* integer passed_mfactor = "m"; *)
 D0 (Sub, SB);
rnp1 #(.l(2.55e-05), .w(4.2e-07), .m(1), .par1(1))
(* integer passed_mfactor = "m"; *)
 R0 (SB, net20);

endmodule
// Library - HV_CELLS, Cell - ioh_d2pk, View - schematic
// LAST TIME SAVED: Feb 25 05:55:50 2015
// NETLIST TIME: Feb 12 01:23:42 2024

`worklib HV_CELLS
`view schematic

`timescale 1ns / 1ps
(* cds_ams_schematic *)

module ioh_d2pk (A_l, K_h, Sub);
inout  A_l, K_h, Sub;
wire net12;
ioh_pmbsabhv_2000 I1 (.GSB( K_h ), .Sub( Sub ), .D( net12 ));
ioh_pe3isabhv_2800gcr I5 (.Sub( Sub ), .SB( net12 ), .D( A_l ));

endmodule
// Library - HV_CELLS, Cell - HVDD4D2PK, View - schematic
// LAST TIME SAVED: Feb 25 05:55:34 2015
// NETLIST TIME: Feb 12 01:23:42 2024

`worklib HV_CELLS
`view schematic

`timescale 1ns / 1ps
(* cds_ams_schematic *)

module HVDD4D2PK (GND, PAD);
inout  GND, PAD;
ioh_d2pk I11 (.Sub( GND ), .K_h( PAD ), .A_l( GND ));
ddnw #(.area(3.89668e-10), .perimeter(0.0002085), .dbv(0), .m(1), .par1(1), .xf_subext(0))
(* integer passed_mfactor = "m"; *)
 D0 (GND, PAD);

endmodule
// Library - HV_CELLS, Cell - ioh_d5pk, View - schematic
// LAST TIME SAVED: Feb 25 05:55:49 2015
// NETLIST TIME: Feb 12 01:23:42 2024

`worklib HV_CELLS
`view schematic

`timescale 1ns / 1ps
(* cds_ams_schematic *)

module ioh_d5pk (A_l, K_h, Sub);
inout  A_l, K_h, Sub;
wire net29;
wire net26;
wire net18;
wire net23;
ioh_pmbsabhv_2000 I3 (.Sub( Sub ), .D( net26 ), .GSB( net29 ));
ioh_pmbsabhv_2000 I4 (.Sub( Sub ), .D( net18 ), .GSB( net26 ));
ioh_pmbsabhv_2000 I2 (.Sub( Sub ), .D( net29 ), .GSB( net23 ));
ioh_pmbsabhv_2000 I1 (.Sub( Sub ), .D( net23 ), .GSB( K_h ));
ioh_pe3isabhv_2800gcr I5 (.Sub( Sub ), .SB( net18 ), .D( A_l ));

endmodule
// Library - HV_CELLS, Cell - HVDD4DJ5PKFs, View - schematic
// LAST TIME SAVED: Feb 25 05:55:38 2015
// NETLIST TIME: Feb 12 01:23:42 2024

`worklib HV_CELLS
`view schematic

`timescale 1ns / 1ps
(* cds_ams_schematic *)

module HVDD4DJ5PKFs (GNDO, IGND, PAD);
inout  GNDO, IGND, PAD;
ioh_dhpw_2x100_stack3 I9 (.A_l( IGND ), .Sub( GNDO ), .K_h( PAD ));
ioh_d5pk I11 (.Sub( GNDO ), .K_h( PAD ), .A_l( IGND ));

endmodule
// Library - INV_LP, Cell - inv, View - schematic
// LAST TIME SAVED: Feb  4 10:15:33 2024
// NETLIST TIME: Feb 12 01:23:42 2024

`worklib INV_LP
`view schematic

`timescale 1ns / 1ps
(* cds_ams_schematic *)

module inv (IN, OUT, VD, VS);
inout  IN, OUT, VD, VS;
ne3 #(.w(2e-06), .l(3.5e-07), .as(9.6e-13), .ad(9.6e-13), .ps(4.96e-06), .pd(4.96e-06), .nrs(0.135), .nrd(0.135), .m((1)*(1)), .par1((1)*(1)), .xf_subext(0))
(* integer passed_mfactor = "m"; *)
 M0 (OUT, IN, VS, VS);
pe3 #(.w(2e-06), .l(3e-07), .as(9.6e-13), .ad(9.6e-13), .ps(4.96e-06), .pd(4.96e-06), .nrs(0.135), .nrd(0.135), .m((1)*(1)), .par1((1)*(1)))
(* integer passed_mfactor = "m"; *)
 M1 (OUT, IN, VD, VD);

endmodule
// Library - IORING, Cell - ioring3, View - schematic
// LAST TIME SAVED: Feb 12 01:23:02 2024
// NETLIST TIME: Feb 12 01:23:42 2024

`worklib IORING
`view schematic

`timescale 1ns / 1ps
(* cds_ams_schematic *)

module ioring3 (CLK, ENABLE, GNDA, GNDD, GNDHV, GNDOHV, GNDOR, GNDORA, INL, OUT0, OUT1, OUT2, OUTHV, OUTL, PSUB, RESET, VDDA, VDDD, VDDHV, VDDOR, VDDORA, clk_core, enable_core, inl_core, out0_core, out1_core, out2_core, reset_core);
inout  CLK, ENABLE, GNDA, GNDD, GNDHV, GNDOHV, GNDOR, GNDORA, INL, OUT0, OUT1, OUT2, OUTHV, OUTL, PSUB, RESET, VDDA, VDDD, VDDHV, VDDOR, VDDORA, clk_core, enable_core, inl_core, out0_core, out1_core, out2_core, reset_core;
wire net3;
wire net2;
wire net1;
wire net9;
wire net10;
wire net14;
wire net11;
wire net15;
wire net8;
wire net7;
wire net4;
wire net6;
wire net5;
PSUBPADPC I4 (.VDDOI( VDDOR ), .PSUB( PSUB ), .VDD3I( VDDD ), .GNDI( GNDD ), .VDDRI( VDDOR ), .GNDOI( GNDOR ), .GNDRI( GNDOR ));
VDDPADPC I21 (.PSUB( PSUB ), .VDD3I( VDDA ), .GNDI( GNDA ), .VDDRI( VDDORA ), .GNDOI( GNDORA ), .VDDOI( VDDORA ), .GNDRI( GNDORA ));
VDDPADPC I3 (.PSUB( PSUB ), .VDD3I( VDDD ), .GNDI( GNDD ), .VDDRI( VDDOR ), .GNDOI( GNDOR ), .VDDOI( VDDOR ), .GNDRI( GNDOR ));
VDDORPADPC I18 (.PSUB( PSUB ), .GNDRI( GNDORA ), .VDD3I( VDDA ), .GNDI( GNDA ), .VDDORI( VDDORA ), .GNDOI( GNDORA ));
VDDORPADPC I1 (.PSUB( PSUB ), .GNDRI( GNDOR ), .VDD3I( VDDD ), .GNDI( GNDD ), .VDDORI( VDDOR ), .GNDOI( GNDOR ));
GNDPADPC I19 (.PSUB( PSUB ), .VDD3I( VDDA ), .GNDI( GNDA ), .VDDRI( VDDORA ), .GNDOI( GNDORA ), .VDDOI( VDDORA ), .GNDRI( GNDORA ));
GNDPADPC I5 (.PSUB( PSUB ), .VDD3I( VDDD ), .GNDI( GNDD ), .VDDRI( VDDOR ), .GNDOI( GNDOR ), .VDDOI( VDDOR ), .GNDRI( GNDOR ));
GNDORPADPC I20 (.VDDOI( VDDORA ), .GNDI( GNDA ), .VDD3I( VDDA ), .GNDORI( GNDORA ), .VDDRI( VDDORA ), .PSUB( PSUB ));
GNDORPADPC I0 (.VDDOI( VDDOR ), .GNDI( GNDD ), .VDD3I( VDDD ), .GNDORI( GNDOR ), .VDDRI( VDDOR ), .PSUB( PSUB ));
ICPC I9 (.VDD3I( VDDD ), .GNDI( GNDD ), .GNDRI( GNDOR ), .VDDRI( VDDOR ), .VDDOI( VDDOR ), .PSUB( PSUB ), .GNDOI( GNDOR ), .Y( enable_core ), .PAD( ENABLE ), .PI( GNDD ), .PO( net3 ));
ICPC I10 (.VDD3I( VDDD ), .GNDI( GNDD ), .GNDRI( GNDOR ), .VDDRI( VDDOR ), .VDDOI( VDDOR ), .PSUB( PSUB ), .GNDOI( GNDOR ), .Y( clk_core ), .PAD( CLK ), .PI( GNDD ), .PO( net2 ));
ICPC I11 (.VDD3I( VDDD ), .GNDI( GNDD ), .GNDRI( GNDOR ), .VDDRI( VDDOR ), .VDDOI( VDDOR ), .PSUB( PSUB ), .GNDOI( GNDOR ), .Y( reset_core ), .PAD( RESET ), .PI( GNDD ), .PO( net1 ));
BT4PC I15 (.PAD( OUT0 ), .A( out0_core ), .EN( GNDD ), .GNDRI( GNDOR ), .PSUB( PSUB ), .VDD3I( VDDD ), .GNDI( GNDD ), .GNDOI( GNDOR ), .VDDOI( VDDOR ), .VDDRI( VDDOR ));
BT4PC I16 (.PAD( OUT1 ), .A( out1_core ), .EN( GNDD ), .GNDRI( GNDOR ), .PSUB( PSUB ), .VDD3I( VDDD ), .GNDI( GNDD ), .GNDOI( GNDOR ), .VDDOI( VDDOR ), .VDDRI( VDDOR ));
BT4PC I17 (.PAD( OUT2 ), .A( out2_core ), .EN( GNDD ), .GNDRI( GNDOR ), .PSUB( PSUB ), .VDD3I( VDDD ), .GNDI( GNDD ), .GNDOI( GNDOR ), .VDDOI( VDDOR ), .VDDRI( VDDOR ));
PWRCUTDCPC I35 (.VDD3I1( net15 ), .GNDRI2( GNDOR ), .VDDOI2( VDDOR ), .GNDOI2( GNDOR ), .GNDI2( GNDD ), .VDDRI2( VDDOR ), .VDDOI1( net11 ), .GNDOI1( GNDOHV ), .VDDRI1( net14 ), .PSUB( PSUB ), .VDD3I2( VDDD ), .GNDRI1( net10 ), .GNDI1( net9 ));
PWRCUTDCPC I34 (.VDD3I1( VDDA ), .GNDRI2( net5 ), .VDDOI2( net6 ), .GNDOI2( GNDOHV ), .GNDI2( net4 ), .VDDRI2( net7 ), .VDDOI1( VDDORA ), .GNDOI1( GNDORA ), .VDDRI1( VDDORA ), .PSUB( PSUB ), .VDD3I2( net8 ), .GNDRI1( GNDORA ), .GNDI1( GNDA ));
PWRCUTDCPC I12 (.VDD3I1( VDDD ), .GNDRI2( GNDORA ), .VDDOI2( VDDORA ), .GNDOI2( GNDORA ), .GNDI2( GNDA ), .VDDRI2( VDDORA ), .VDDOI1( VDDOR ), .GNDOI1( GNDOR ), .VDDRI1( VDDOR ), .PSUB( PSUB ), .VDD3I2( VDDA ), .GNDRI1( GNDOR ), .GNDI1( GNDD ));
CORNERESDPC I40 (.VDDOI( VDDORA ), .PSUB( PSUB ), .GNDRI( GNDORA ), .VDD3I( VDDA ), .GNDI( GNDA ), .GNDOI( GNDORA ), .VDDRI( VDDORA ));
CORNERESDPC I39 (.VDDOI( VDDOR ), .PSUB( PSUB ), .GNDRI( GNDOR ), .VDD3I( VDDD ), .GNDI( GNDD ), .GNDOI( GNDOR ), .VDDRI( VDDOR ));
APR00DPC I26 (.VDD3I( VDDA ), .VDDOI( VDDORA ), .GNDRI( GNDORA ), .GNDI( GNDA ), .PSUB( PSUB ), .VDDRI( VDDORA ), .GNDOI( GNDORA ), .PAD( OUTL ));
APR04DPC I27 (.VDDRI( VDDORA ), .VDD3I( VDDA ), .VDDOI( VDDORA ), .PSUB( PSUB ), .GNDRI( GNDORA ), .GNDI( GNDA ), .GNDOI( GNDORA ), .Y( inl_core ), .PAD( INL ));
HVD4SJD1R5PKFs I33 (.IGND( GNDHV ), .GNDO( GNDOHV ), .PAD( OUTHV ));
HVDD4D2PK I36 (.PAD( GNDHV ), .GND( GNDOHV ));
HVDD4DJ5PKFs I28 (.PAD( VDDHV ), .GNDO( GNDOHV ), .IGND( GNDHV ));
s_res #(.r(5), .m(1))
(* integer passed_mfactor = "m"; *)
 R0 (GNDOHV, PSUB);

endmodule
// Library - D_CELLS_JI3V, Cell - DECAP10JI3V, View - cmos_sch
// LAST TIME SAVED: Mar 20 08:58:51 2023
// NETLIST TIME: Feb 12 01:23:42 2024

`worklib D_CELLS_JI3V
`view cmos_sch

`timescale 1ns / 1ps
(* cds_ams_schematic *)

module DECAP10JI3V ( );
wire (*
integer inh_conn_prop_name = "power_vdd3i";
integer inh_conn_def_value = "cds_globals.\\vdd3i! "; *)
\vdd3i! ;
wire (*
integer inh_conn_prop_name = "ground_gnd3i";
integer inh_conn_def_value = "cds_globals.\\gnd3i! "; *)
\gnd3i! ;
ne3i #(.w(8.8e-07), .l(3.5e-07), .as(4.224e-13), .ad(4.224e-13), .ps(2.72e-06), .pd(2.72e-06), .nrs(0.306818), .nrd(0.306818), .m((1)*(1)), .par1((1)*(1)))
(* integer passed_mfactor = "m"; *)
 M7 (net3, net4, \gnd3i! , \gnd3i! );
ne3i #(.w(1.76e-06), .l(1.445e-06), .as(8.448e-13), .ad(8.448e-13), .ps(4.48e-06), .pd(4.48e-06), .nrs(0.153409), .nrd(0.153409), .m((1)*(1)), .par1((1)*(1)))
(* integer passed_mfactor = "m"; *)
 M6 (\gnd3i! , net4, \gnd3i! , \gnd3i! );
pe3i #(.w(1.315e-06), .l(3e-07), .as(6.312e-13), .ad(6.312e-13), .ps(3.59e-06), .pd(3.59e-06), .nrs(0.205323), .nrd(0.205323), .m((1)*(1)), .par1((1)*(1)))
(* integer passed_mfactor = "m"; *)
 M5 (net4, net3, \vdd3i! , \vdd3i! );
pe3i #(.w(2.63e-06), .l(1.425e-06), .as(1.2624e-12), .ad(1.2624e-12), .ps(6.22e-06), .pd(6.22e-06), .nrs(0.102662), .nrd(0.102662), .m((1)*(1)), .par1((1)*(1)))
(* integer passed_mfactor = "m"; *)
 M4 (\vdd3i! , net3, \vdd3i! , \vdd3i! );

endmodule
// Library - D_CELLS_JI3V, Cell - DECAP15JI3V, View - cmos_sch
// LAST TIME SAVED: Mar 20 08:58:51 2023
// NETLIST TIME: Feb 12 01:23:42 2024

`worklib D_CELLS_JI3V
`view cmos_sch

`timescale 1ns / 1ps
(* cds_ams_schematic *)

module DECAP15JI3V ( );
wire (*
integer inh_conn_prop_name = "power_vdd3i";
integer inh_conn_def_value = "cds_globals.\\vdd3i! "; *)
\vdd3i! ;
wire (*
integer inh_conn_prop_name = "ground_gnd3i";
integer inh_conn_def_value = "cds_globals.\\gnd3i! "; *)
\gnd3i! ;
ne3i #(.w(8.8e-07), .l(3.5e-07), .as(4.224e-13), .ad(4.224e-13), .ps(2.72e-06), .pd(2.72e-06), .nrs(0.306818), .nrd(0.306818), .m((1)*(1)), .par1((1)*(1)))
(* integer passed_mfactor = "m"; *)
 M7 (net3, net4, \gnd3i! , \gnd3i! );
ne3i #(.w(2.64e-06), .l(1.71e-06), .as(1.2672e-12), .ad(1.2672e-12), .ps(6.24e-06), .pd(6.24e-06), .nrs(0.102273), .nrd(0.102273), .m((1)*(1)), .par1((1)*(1)))
(* integer passed_mfactor = "m"; *)
 M6 (\gnd3i! , net4, \gnd3i! , \gnd3i! );
pe3i #(.w(1.315e-06), .l(3e-07), .as(6.312e-13), .ad(6.312e-13), .ps(3.59e-06), .pd(3.59e-06), .nrs(0.205323), .nrd(0.205323), .m((1)*(1)), .par1((1)*(1)))
(* integer passed_mfactor = "m"; *)
 M5 (net4, net3, \vdd3i! , \vdd3i! );
pe3i #(.w(3.945e-06), .l(1.7e-06), .as(1.8936e-12), .ad(1.8936e-12), .ps(8.85e-06), .pd(8.85e-06), .nrs(0.0684411), .nrd(0.0684411), .m((1)*(1)), .par1((1)*(1)))
(* integer passed_mfactor = "m"; *)
 M4 (\vdd3i! , net3, \vdd3i! , \vdd3i! );

endmodule
// Library - D_CELLS_JI3V, Cell - DECAP25JI3V, View - cmos_sch
// LAST TIME SAVED: Mar 20 08:58:51 2023
// NETLIST TIME: Feb 12 01:23:42 2024

`worklib D_CELLS_JI3V
`view cmos_sch

`timescale 1ns / 1ps
(* cds_ams_schematic *)

module DECAP25JI3V ( );
wire (*
integer inh_conn_prop_name = "power_vdd3i";
integer inh_conn_def_value = "cds_globals.\\vdd3i! "; *)
\vdd3i! ;
wire (*
integer inh_conn_prop_name = "ground_gnd3i";
integer inh_conn_def_value = "cds_globals.\\gnd3i! "; *)
\gnd3i! ;
ne3i #(.w(8.8e-07), .l(3.5e-07), .as(4.224e-13), .ad(4.224e-13), .ps(2.72e-06), .pd(2.72e-06), .nrs(0.306818), .nrd(0.306818), .m((1)*(1)), .par1((1)*(1)))
(* integer passed_mfactor = "m"; *)
 M7 (net3, net4, \gnd3i! , \gnd3i! );
ne3i #(.w(4.4e-06), .l(1.94e-06), .as(2.112e-12), .ad(2.112e-12), .ps(9.76e-06), .pd(9.76e-06), .nrs(0.0613636), .nrd(0.0613636), .m((1)*(1)), .par1((1)*(1)))
(* integer passed_mfactor = "m"; *)
 M6 (\gnd3i! , net4, \gnd3i! , \gnd3i! );
pe3i #(.w(1.315e-06), .l(3e-07), .as(6.312e-13), .ad(6.312e-13), .ps(3.59e-06), .pd(3.59e-06), .nrs(0.205323), .nrd(0.205323), .m((1)*(1)), .par1((1)*(1)))
(* integer passed_mfactor = "m"; *)
 M5 (net4, net3, \vdd3i! , \vdd3i! );
pe3i #(.w(6.575e-06), .l(1.93e-06), .as(3.156e-12), .ad(3.156e-12), .ps(1.411e-05), .pd(1.411e-05), .nrs(0.0410646), .nrd(0.0410646), .m((1)*(1)), .par1((1)*(1)))
(* integer passed_mfactor = "m"; *)
 M4 (\vdd3i! , net3, \vdd3i! , \vdd3i! );

endmodule
// Library - D_CELLS_JI3V, Cell - BUJI3VX1, View - cmos_sch
// LAST TIME SAVED: Mar 20 08:58:52 2023
// NETLIST TIME: Feb 12 01:23:42 2024

`worklib D_CELLS_JI3V
`view cmos_sch

`timescale 1ns / 1ps
(* cds_ams_schematic *)

module BUJI3VX1 (Q, A);
output  Q;
input  A;
wire (*
integer inh_conn_prop_name = "power_vdd3i";
integer inh_conn_def_value = "cds_globals.\\vdd3i! "; *)
\vdd3i! ;
wire (*
integer inh_conn_prop_name = "ground_gnd3i";
integer inh_conn_def_value = "cds_globals.\\gnd3i! "; *)
\gnd3i! ;
wire net9;
invrji3v #(.GT_PDL(3.5e-07), .GT_PUW(9e-07), .GT_PDW(4.2e-07), .GT_PUL(3e-07)) invr_1 (.out( net9 ), .in( A ));
invrji3v #(.GT_PDL(3.5e-07), .GT_PUW(1.46e-06), .GT_PDW(6.6e-07), .GT_PUL(3e-07)) invr_2 (.out( Q ), .in( net9 ));

endmodule
// Library - D_CELLS_JI3V, Cell - DFRQJI3VX1, View - cmos_sch
// LAST TIME SAVED: Mar 20 08:58:50 2023
// NETLIST TIME: Feb 12 01:23:42 2024

`worklib D_CELLS_JI3V
`view cmos_sch

`timescale 1ns / 1ps
(* cds_ams_schematic *)

module DFRQJI3VX1 (Q, C, D);
output  Q;
input  C, D;
wire (*
integer inh_conn_prop_name = "power_vdd3i";
integer inh_conn_def_value = "cds_globals.\\vdd3i! "; *)
\vdd3i! ;
wire (*
integer inh_conn_prop_name = "ground_gnd3i";
integer inh_conn_def_value = "cds_globals.\\gnd3i! "; *)
\gnd3i! ;
wire SQIB;
wire CIB;
wire CI;
invrji3v #(.GT_PDL(3.5e-07), .GT_PUW(1.41e-06), .GT_PDW(8.9e-07), .GT_PUL(3e-07)) invr_3 (.out( Q ), .in( SQIB ));
invrji3v #(.GT_PDL(3.5e-07), .GT_PUW(7.2e-07), .GT_PDW(4.2e-07), .GT_PUL(3e-07)) invr_2 (.out( CI ), .in( CIB ));
invrji3v #(.GT_PDL(3.5e-07), .GT_PUW(7.2e-07), .GT_PDW(4.2e-07), .GT_PUL(3e-07)) invr_1 (.out( CIB ), .in( C ));
pe3i #(.w(1.1e-06), .l(3e-07), .as(5.28e-13), .ad(5.28e-13), .ps(3.16e-06), .pd(3.16e-06), .nrs(0.245455), .nrd(0.245455), .m((1)*(1)), .par1((1)*(1)))
(* integer passed_mfactor = "m"; *)
 M24 (MQIB, CI, net162, \vdd3i! );
pe3i #(.w(7.2e-07), .l(3e-07), .as(3.456e-13), .ad(3.456e-13), .ps(2.4e-06), .pd(2.4e-06), .nrs(0.375), .nrd(0.375), .m((1)*(1)), .par1((1)*(1)))
(* integer passed_mfactor = "m"; *)
 M56 (MQI, MQIB, \vdd3i! , \vdd3i! );
pe3i #(.w(1.15e-06), .l(3e-07), .as(5.52e-13), .ad(5.52e-13), .ps(3.26e-06), .pd(3.26e-06), .nrs(0.234783), .nrd(0.234783), .m((1)*(1)), .par1((1)*(1)))
(* integer passed_mfactor = "m"; *)
 M30 (net170, MQI, \vdd3i! , \vdd3i! );
pe3i #(.w(1.1e-06), .l(3e-07), .as(5.28e-13), .ad(5.28e-13), .ps(3.16e-06), .pd(3.16e-06), .nrs(0.245455), .nrd(0.245455), .m((1)*(1)), .par1((1)*(1)))
(* integer passed_mfactor = "m"; *)
 M23 (net162, D, \vdd3i! , \vdd3i! );
pe3i #(.w(7.2e-07), .l(3e-07), .as(3.456e-13), .ad(3.456e-13), .ps(2.4e-06), .pd(2.4e-06), .nrs(0.375), .nrd(0.375), .m((1)*(1)), .par1((1)*(1)))
(* integer passed_mfactor = "m"; *)
 M59 (net142, SQIB, \vdd3i! , \vdd3i! );
pe3i #(.w(4.2e-07), .l(3e-07), .as(2.016e-13), .ad(2.016e-13), .ps(1.8e-06), .pd(1.8e-06), .nrs(0.642857), .nrd(0.642857), .m((1)*(1)), .par1((1)*(1)))
(* integer passed_mfactor = "m"; *)
 M36 (net166, net142, \vdd3i! , \vdd3i! );
pe3i #(.w(4.2e-07), .l(3e-07), .as(2.016e-13), .ad(2.016e-13), .ps(1.8e-06), .pd(1.8e-06), .nrs(0.642857), .nrd(0.642857), .m((1)*(1)), .par1((1)*(1)))
(* integer passed_mfactor = "m"; *)
 M35 (SQIB, CI, net166, \vdd3i! );
pe3i #(.w(4.2e-07), .l(3e-07), .as(2.016e-13), .ad(2.016e-13), .ps(1.8e-06), .pd(1.8e-06), .nrs(0.642857), .nrd(0.642857), .m((1)*(1)), .par1((1)*(1)))
(* integer passed_mfactor = "m"; *)
 M34 (MQIB, CIB, net174, \vdd3i! );
pe3i #(.w(1.15e-06), .l(3e-07), .as(5.52e-13), .ad(5.52e-13), .ps(3.26e-06), .pd(3.26e-06), .nrs(0.234783), .nrd(0.234783), .m((1)*(1)), .par1((1)*(1)))
(* integer passed_mfactor = "m"; *)
 M33 (SQIB, CIB, net170, \vdd3i! );
pe3i #(.w(4.2e-07), .l(3e-07), .as(2.016e-13), .ad(2.016e-13), .ps(1.8e-06), .pd(1.8e-06), .nrs(0.642857), .nrd(0.642857), .m((1)*(1)), .par1((1)*(1)))
(* integer passed_mfactor = "m"; *)
 M28 (net174, MQI, \vdd3i! , \vdd3i! );
ne3i #(.w(7e-07), .l(3.5e-07), .as(3.36e-13), .ad(3.36e-13), .ps(2.36e-06), .pd(2.36e-06), .nrs(0.385714), .nrd(0.385714), .m((1)*(1)), .par1((1)*(1)))
(* integer passed_mfactor = "m"; *)
 M18 (MQIB, CIB, net124, \gnd3i! );
ne3i #(.w(4.2e-07), .l(3.5e-07), .as(2.016e-13), .ad(2.016e-13), .ps(1.8e-06), .pd(1.8e-06), .nrs(0.642857), .nrd(0.642857), .m((1)*(1)), .par1((1)*(1)))
(* integer passed_mfactor = "m"; *)
 M17 (MQI, MQIB, \gnd3i! , \gnd3i! );
ne3i #(.w(7e-07), .l(3.5e-07), .as(3.36e-13), .ad(3.36e-13), .ps(2.36e-06), .pd(2.36e-06), .nrs(0.385714), .nrd(0.385714), .m((1)*(1)), .par1((1)*(1)))
(* integer passed_mfactor = "m"; *)
 M15 (net124, D, \gnd3i! , \gnd3i! );
ne3i #(.w(7.2e-07), .l(3.5e-07), .as(3.456e-13), .ad(3.456e-13), .ps(2.4e-06), .pd(2.4e-06), .nrs(0.375), .nrd(0.375), .m((1)*(1)), .par1((1)*(1)))
(* integer passed_mfactor = "m"; *)
 M46 (SQIB, CI, net132, \gnd3i! );
ne3i #(.w(4.2e-07), .l(3.5e-07), .as(2.016e-13), .ad(2.016e-13), .ps(1.8e-06), .pd(1.8e-06), .nrs(0.642857), .nrd(0.642857), .m((1)*(1)), .par1((1)*(1)))
(* integer passed_mfactor = "m"; *)
 M19 (MQIB, CI, net120, \gnd3i! );
ne3i #(.w(4.2e-07), .l(3.5e-07), .as(2.016e-13), .ad(2.016e-13), .ps(1.8e-06), .pd(1.8e-06), .nrs(0.642857), .nrd(0.642857), .m((1)*(1)), .par1((1)*(1)))
(* integer passed_mfactor = "m"; *)
 M51 (SQIB, CIB, net140, \gnd3i! );
ne3i #(.w(4.2e-07), .l(3.5e-07), .as(2.016e-13), .ad(2.016e-13), .ps(1.8e-06), .pd(1.8e-06), .nrs(0.642857), .nrd(0.642857), .m((1)*(1)), .par1((1)*(1)))
(* integer passed_mfactor = "m"; *)
 M50 (net140, net142, \gnd3i! , \gnd3i! );
ne3i #(.w(4.2e-07), .l(3.5e-07), .as(2.016e-13), .ad(2.016e-13), .ps(1.8e-06), .pd(1.8e-06), .nrs(0.642857), .nrd(0.642857), .m((1)*(1)), .par1((1)*(1)))
(* integer passed_mfactor = "m"; *)
 M49 (net142, SQIB, \gnd3i! , \gnd3i! );
ne3i #(.w(7.2e-07), .l(3.5e-07), .as(3.456e-13), .ad(3.456e-13), .ps(2.4e-06), .pd(2.4e-06), .nrs(0.375), .nrd(0.375), .m((1)*(1)), .par1((1)*(1)))
(* integer passed_mfactor = "m"; *)
 M47 (net132, MQI, \gnd3i! , \gnd3i! );
ne3i #(.w(4.2e-07), .l(3.5e-07), .as(2.016e-13), .ad(2.016e-13), .ps(1.8e-06), .pd(1.8e-06), .nrs(0.642857), .nrd(0.642857), .m((1)*(1)), .par1((1)*(1)))
(* integer passed_mfactor = "m"; *)
 M61 (net120, MQI, \gnd3i! , \gnd3i! );

endmodule
// Library - D_CELLS_JI3V, Cell - NO2JI3VX0, View - cmos_sch
// LAST TIME SAVED: Mar 20 08:58:32 2023
// NETLIST TIME: Feb 12 01:23:42 2024

`worklib D_CELLS_JI3V
`view cmos_sch

`timescale 1ns / 1ps
(* cds_ams_schematic *)

module NO2JI3VX0 (Q, A, B);
output  Q;
input  A, B;
wire (*
integer inh_conn_prop_name = "power_vdd3i";
integer inh_conn_def_value = "cds_globals.\\vdd3i! "; *)
\vdd3i! ;
wire (*
integer inh_conn_prop_name = "ground_gnd3i";
integer inh_conn_def_value = "cds_globals.\\gnd3i! "; *)
\gnd3i! ;
nor2ji3v #(.GT_PDL(3.5e-07), .GT_PUW(8.5e-07), .GT_PDW(4.2e-07), .GT_PUL(3e-07)) nor2_1 (.a( A ), .b( B ), .out( Q ));

endmodule
// Library - D_CELLS_JI3V, Cell - EN2JI3VX0, View - cmos_sch
// LAST TIME SAVED: Mar 20 08:58:47 2023
// NETLIST TIME: Feb 12 01:23:42 2024

`worklib D_CELLS_JI3V
`view cmos_sch

`timescale 1ns / 1ps
(* cds_ams_schematic *)

module EN2JI3VX0 (Q, A, B);
output  Q;
input  A, B;
wire (*
integer inh_conn_prop_name = "power_vdd3i";
integer inh_conn_def_value = "cds_globals.\\vdd3i! "; *)
\vdd3i! ;
wire (*
integer inh_conn_prop_name = "ground_gnd3i";
integer inh_conn_def_value = "cds_globals.\\gnd3i! "; *)
\gnd3i! ;
wire net4;
nand2ji3v #(.GT_PDL(3.5e-07), .GT_PUW(9e-07), .GT_PDW(4.2e-07), .GT_PUL(3e-07)) nand2_1 (.a( A ), .b( B ), .out( net4 ));
o2na2ji3v #(.GT_PUW(1.3e-06), .GT_PDL(3.5e-07), .GT_PUL(3e-07), .GT_PDW(4.2e-07)) o2na2_1 (.out( Q ), .c( net4 ), .b( A ), .a( B ));

endmodule
// Library - D_CELLS_JI3V, Cell - DFRQJI3VX2, View - cmos_sch
// LAST TIME SAVED: Mar 20 08:58:50 2023
// NETLIST TIME: Feb 12 01:23:42 2024

`worklib D_CELLS_JI3V
`view cmos_sch

`timescale 1ns / 1ps
(* cds_ams_schematic *)

module DFRQJI3VX2 (Q, C, D);
output  Q;
input  C, D;
wire (*
integer inh_conn_prop_name = "power_vdd3i";
integer inh_conn_def_value = "cds_globals.\\vdd3i! "; *)
\vdd3i! ;
wire (*
integer inh_conn_prop_name = "ground_gnd3i";
integer inh_conn_def_value = "cds_globals.\\gnd3i! "; *)
\gnd3i! ;
wire SQIB;
wire CIB;
wire CI;
invrji3v #(.GT_PDL(3.5e-07), .GT_PUW(2.82e-06), .GT_PDW(1.78e-06), .GT_PUL(3e-07)) invr_3 (.out( Q ), .in( SQIB ));
invrji3v #(.GT_PDL(3.5e-07), .GT_PUW(7.2e-07), .GT_PDW(4.2e-07), .GT_PUL(3e-07)) invr_2 (.out( CI ), .in( CIB ));
invrji3v #(.GT_PDL(3.5e-07), .GT_PUW(7.2e-07), .GT_PDW(4.2e-07), .GT_PUL(3e-07)) invr_1 (.out( CIB ), .in( C ));
pe3i #(.w(1.1e-06), .l(3e-07), .as(5.28e-13), .ad(5.28e-13), .ps(3.16e-06), .pd(3.16e-06), .nrs(0.245455), .nrd(0.245455), .m((1)*(1)), .par1((1)*(1)))
(* integer passed_mfactor = "m"; *)
 M24 (MQIB, CI, net162, \vdd3i! );
pe3i #(.w(7.2e-07), .l(3e-07), .as(3.456e-13), .ad(3.456e-13), .ps(2.4e-06), .pd(2.4e-06), .nrs(0.375), .nrd(0.375), .m((1)*(1)), .par1((1)*(1)))
(* integer passed_mfactor = "m"; *)
 M56 (MQI, MQIB, \vdd3i! , \vdd3i! );
pe3i #(.w(1.15e-06), .l(3e-07), .as(5.52e-13), .ad(5.52e-13), .ps(3.26e-06), .pd(3.26e-06), .nrs(0.234783), .nrd(0.234783), .m((1)*(1)), .par1((1)*(1)))
(* integer passed_mfactor = "m"; *)
 M30 (net170, MQI, \vdd3i! , \vdd3i! );
pe3i #(.w(1.1e-06), .l(3e-07), .as(5.28e-13), .ad(5.28e-13), .ps(3.16e-06), .pd(3.16e-06), .nrs(0.245455), .nrd(0.245455), .m((1)*(1)), .par1((1)*(1)))
(* integer passed_mfactor = "m"; *)
 M23 (net162, D, \vdd3i! , \vdd3i! );
pe3i #(.w(7.2e-07), .l(3e-07), .as(3.456e-13), .ad(3.456e-13), .ps(2.4e-06), .pd(2.4e-06), .nrs(0.375), .nrd(0.375), .m((1)*(1)), .par1((1)*(1)))
(* integer passed_mfactor = "m"; *)
 M59 (net142, SQIB, \vdd3i! , \vdd3i! );
pe3i #(.w(4.2e-07), .l(3e-07), .as(2.016e-13), .ad(2.016e-13), .ps(1.8e-06), .pd(1.8e-06), .nrs(0.642857), .nrd(0.642857), .m((1)*(1)), .par1((1)*(1)))
(* integer passed_mfactor = "m"; *)
 M36 (net166, net142, \vdd3i! , \vdd3i! );
pe3i #(.w(4.2e-07), .l(3e-07), .as(2.016e-13), .ad(2.016e-13), .ps(1.8e-06), .pd(1.8e-06), .nrs(0.642857), .nrd(0.642857), .m((1)*(1)), .par1((1)*(1)))
(* integer passed_mfactor = "m"; *)
 M35 (SQIB, CI, net166, \vdd3i! );
pe3i #(.w(4.2e-07), .l(3e-07), .as(2.016e-13), .ad(2.016e-13), .ps(1.8e-06), .pd(1.8e-06), .nrs(0.642857), .nrd(0.642857), .m((1)*(1)), .par1((1)*(1)))
(* integer passed_mfactor = "m"; *)
 M34 (MQIB, CIB, net174, \vdd3i! );
pe3i #(.w(1.15e-06), .l(3e-07), .as(5.52e-13), .ad(5.52e-13), .ps(3.26e-06), .pd(3.26e-06), .nrs(0.234783), .nrd(0.234783), .m((1)*(1)), .par1((1)*(1)))
(* integer passed_mfactor = "m"; *)
 M33 (SQIB, CIB, net170, \vdd3i! );
pe3i #(.w(4.2e-07), .l(3e-07), .as(2.016e-13), .ad(2.016e-13), .ps(1.8e-06), .pd(1.8e-06), .nrs(0.642857), .nrd(0.642857), .m((1)*(1)), .par1((1)*(1)))
(* integer passed_mfactor = "m"; *)
 M28 (net174, MQI, \vdd3i! , \vdd3i! );
ne3i #(.w(7e-07), .l(3.5e-07), .as(3.36e-13), .ad(3.36e-13), .ps(2.36e-06), .pd(2.36e-06), .nrs(0.385714), .nrd(0.385714), .m((1)*(1)), .par1((1)*(1)))
(* integer passed_mfactor = "m"; *)
 M18 (MQIB, CIB, net124, \gnd3i! );
ne3i #(.w(4.2e-07), .l(3.5e-07), .as(2.016e-13), .ad(2.016e-13), .ps(1.8e-06), .pd(1.8e-06), .nrs(0.642857), .nrd(0.642857), .m((1)*(1)), .par1((1)*(1)))
(* integer passed_mfactor = "m"; *)
 M17 (MQI, MQIB, \gnd3i! , \gnd3i! );
ne3i #(.w(7e-07), .l(3.5e-07), .as(3.36e-13), .ad(3.36e-13), .ps(2.36e-06), .pd(2.36e-06), .nrs(0.385714), .nrd(0.385714), .m((1)*(1)), .par1((1)*(1)))
(* integer passed_mfactor = "m"; *)
 M15 (net124, D, \gnd3i! , \gnd3i! );
ne3i #(.w(7.2e-07), .l(3.5e-07), .as(3.456e-13), .ad(3.456e-13), .ps(2.4e-06), .pd(2.4e-06), .nrs(0.375), .nrd(0.375), .m((1)*(1)), .par1((1)*(1)))
(* integer passed_mfactor = "m"; *)
 M46 (SQIB, CI, net132, \gnd3i! );
ne3i #(.w(4.2e-07), .l(3.5e-07), .as(2.016e-13), .ad(2.016e-13), .ps(1.8e-06), .pd(1.8e-06), .nrs(0.642857), .nrd(0.642857), .m((1)*(1)), .par1((1)*(1)))
(* integer passed_mfactor = "m"; *)
 M19 (MQIB, CI, net120, \gnd3i! );
ne3i #(.w(4.2e-07), .l(3.5e-07), .as(2.016e-13), .ad(2.016e-13), .ps(1.8e-06), .pd(1.8e-06), .nrs(0.642857), .nrd(0.642857), .m((1)*(1)), .par1((1)*(1)))
(* integer passed_mfactor = "m"; *)
 M51 (SQIB, CIB, net140, \gnd3i! );
ne3i #(.w(4.2e-07), .l(3.5e-07), .as(2.016e-13), .ad(2.016e-13), .ps(1.8e-06), .pd(1.8e-06), .nrs(0.642857), .nrd(0.642857), .m((1)*(1)), .par1((1)*(1)))
(* integer passed_mfactor = "m"; *)
 M50 (net140, net142, \gnd3i! , \gnd3i! );
ne3i #(.w(4.2e-07), .l(3.5e-07), .as(2.016e-13), .ad(2.016e-13), .ps(1.8e-06), .pd(1.8e-06), .nrs(0.642857), .nrd(0.642857), .m((1)*(1)), .par1((1)*(1)))
(* integer passed_mfactor = "m"; *)
 M49 (net142, SQIB, \gnd3i! , \gnd3i! );
ne3i #(.w(7.2e-07), .l(3.5e-07), .as(3.456e-13), .ad(3.456e-13), .ps(2.4e-06), .pd(2.4e-06), .nrs(0.375), .nrd(0.375), .m((1)*(1)), .par1((1)*(1)))
(* integer passed_mfactor = "m"; *)
 M47 (net132, MQI, \gnd3i! , \gnd3i! );
ne3i #(.w(4.2e-07), .l(3.5e-07), .as(2.016e-13), .ad(2.016e-13), .ps(1.8e-06), .pd(1.8e-06), .nrs(0.642857), .nrd(0.642857), .m((1)*(1)), .par1((1)*(1)))
(* integer passed_mfactor = "m"; *)
 M61 (net120, MQI, \gnd3i! , \gnd3i! );

endmodule
// Library - D_CELLS_JI3V, Cell - AN22JI3VX1, View - cmos_sch
// LAST TIME SAVED: Mar 20 08:58:57 2023
// NETLIST TIME: Feb 12 01:23:42 2024

`worklib D_CELLS_JI3V
`view cmos_sch

`timescale 1ns / 1ps
(* cds_ams_schematic *)

module AN22JI3VX1 (Q, A, B, C, D);
output  Q;
input  A, B, C, D;
wire (*
integer inh_conn_prop_name = "power_vdd3i";
integer inh_conn_def_value = "cds_globals.\\vdd3i! "; *)
\vdd3i! ;
wire (*
integer inh_conn_prop_name = "ground_gnd3i";
integer inh_conn_def_value = "cds_globals.\\gnd3i! "; *)
\gnd3i! ;
a22no2ji3v #(.GT_PUW(1.47e-06), .GT_PDL(3.5e-07), .GT_PUL(3e-07), .GT_PDW(8.9e-07)) a22no2_1 (.c( C ), .d( D ), .b( B ), .a( A ), .out( Q ));

endmodule
// Library - D_CELLS_JI3V, Cell - AN21JI3VX1, View - cmos_sch
// LAST TIME SAVED: Mar 20 08:58:57 2023
// NETLIST TIME: Feb 12 01:23:42 2024

`worklib D_CELLS_JI3V
`view cmos_sch

`timescale 1ns / 1ps
(* cds_ams_schematic *)

module AN21JI3VX1 (Q, A, B, C);
output  Q;
input  A, B, C;
wire (*
integer inh_conn_prop_name = "power_vdd3i";
integer inh_conn_def_value = "cds_globals.\\vdd3i! "; *)
\vdd3i! ;
wire (*
integer inh_conn_prop_name = "ground_gnd3i";
integer inh_conn_def_value = "cds_globals.\\gnd3i! "; *)
\gnd3i! ;
a2no2ji3v #(.GT_PUW(1.41e-06), .GT_PDL(3.5e-07), .GT_PUL(3e-07), .GT_PDW(8.9e-07)) a2no2_1 (.out( Q ), .b( B ), .a( A ), .c( C ));

endmodule
// Library - D_CELLS_JI3V, Cell - DLY1JI3VX1, View - cmos_sch
// LAST TIME SAVED: Mar 20 08:58:47 2023
// NETLIST TIME: Feb 12 01:23:42 2024

`worklib D_CELLS_JI3V
`view cmos_sch

`timescale 1ns / 1ps
(* cds_ams_schematic *)

module DLY1JI3VX1 (Q, A);
output  Q;
input  A;
wire (*
integer inh_conn_prop_name = "power_vdd3i";
integer inh_conn_def_value = "cds_globals.\\vdd3i! "; *)
\vdd3i! ;
wire (*
integer inh_conn_prop_name = "ground_gnd3i";
integer inh_conn_def_value = "cds_globals.\\gnd3i! "; *)
\gnd3i! ;
wire net35;
wire net47;
invrji3v #(.GT_PDL(3.5e-07), .GT_PUW(1.41e-06), .GT_PDW(8.9e-07), .GT_PUL(3e-07)) invr_2 (.out( Q ), .in( net35 ));
invrji3v #(.GT_PDL(3.5e-07), .GT_PUW(6.7e-07), .GT_PDW(4.2e-07), .GT_PUL(3e-07)) invr_1 (.out( net47 ), .in( A ));
pe3i #(.w(4.2e-07), .l(7.5e-07), .as(2.016e-13), .ad(2.016e-13), .ps(1.8e-06), .pd(1.8e-06), .nrs(0.642857), .nrd(0.642857), .m((1)*(1)), .par1((1)*(1)))
(* integer passed_mfactor = "m"; *)
 M3 (net35, net31, \vdd3i! , \vdd3i! );
pe3i #(.w(4.2e-07), .l(1e-06), .as(2.016e-13), .ad(2.016e-13), .ps(1.8e-06), .pd(1.8e-06), .nrs(0.642857), .nrd(0.642857), .m((1)*(1)), .par1((1)*(1)))
(* integer passed_mfactor = "m"; *)
 M1 (net31, net47, \vdd3i! , \vdd3i! );
ne3i #(.w(4.2e-07), .l(8e-07), .as(2.016e-13), .ad(2.016e-13), .ps(1.8e-06), .pd(1.8e-06), .nrs(0.642857), .nrd(0.642857), .m((1)*(1)), .par1((1)*(1)))
(* integer passed_mfactor = "m"; *)
 M2 (net31, net47, \gnd3i! , \gnd3i! );
ne3i #(.w(4.2e-07), .l(1e-06), .as(2.016e-13), .ad(2.016e-13), .ps(1.8e-06), .pd(1.8e-06), .nrs(0.642857), .nrd(0.642857), .m((1)*(1)), .par1((1)*(1)))
(* integer passed_mfactor = "m"; *)
 M4 (net35, net31, \gnd3i! , \gnd3i! );

endmodule
// Library - D_CELLS_JI3V, Cell - ON211JI3VX1, View - cmos_sch
// LAST TIME SAVED: Mar 20 08:58:30 2023
// NETLIST TIME: Feb 12 01:23:42 2024

`worklib D_CELLS_JI3V
`view cmos_sch

`timescale 1ns / 1ps
(* cds_ams_schematic *)

module ON211JI3VX1 (Q, A, B, C, D);
output  Q;
input  A, B, C, D;
wire (*
integer inh_conn_prop_name = "power_vdd3i";
integer inh_conn_def_value = "cds_globals.\\vdd3i! "; *)
\vdd3i! ;
wire (*
integer inh_conn_prop_name = "ground_gnd3i";
integer inh_conn_def_value = "cds_globals.\\gnd3i! "; *)
\gnd3i! ;
o2na3ji3v #(.GT_PUW(1.38e-06), .GT_PDL(3.5e-07), .GT_PUL(3e-07), .GT_PDW(9e-07)) o2na3_1 (.c( C ), .a( A ), .b( B ), .d( D ), .out( Q ));

endmodule
// Library - D_CELLS_JI3V, Cell - BUJI3VX16, View - cmos_sch
// LAST TIME SAVED: Mar 20 08:58:52 2023
// NETLIST TIME: Feb 12 01:23:42 2024

`worklib D_CELLS_JI3V
`view cmos_sch

`timescale 1ns / 1ps
(* cds_ams_schematic *)

module BUJI3VX16 (Q, A);
output  Q;
input  A;
wire (*
integer inh_conn_prop_name = "power_vdd3i";
integer inh_conn_def_value = "cds_globals.\\vdd3i! "; *)
\vdd3i! ;
wire (*
integer inh_conn_prop_name = "ground_gnd3i";
integer inh_conn_def_value = "cds_globals.\\gnd3i! "; *)
\gnd3i! ;
wire net9;
invrji3v #(.GT_PDL(3.5e-07), .GT_PUW(8.82e-06), .GT_PDW(4.45e-06), .GT_PUL(3e-07)) invr_1 (.out( net9 ), .in( A ));
invrji3v #(.GT_PDL(3.5e-07), .GT_PUW(2.352e-05), .GT_PDW(9.78e-06), .GT_PUL(3e-07)) invr_2 (.out( Q ), .in( net9 ));

endmodule
// Library - D_CELLS_JI3V, Cell - BUJI3VX0, View - cmos_sch
// LAST TIME SAVED: Mar 20 08:58:52 2023
// NETLIST TIME: Feb 12 01:23:42 2024

`worklib D_CELLS_JI3V
`view cmos_sch

`timescale 1ns / 1ps
(* cds_ams_schematic *)

module BUJI3VX0 (Q, A);
output  Q;
input  A;
wire (*
integer inh_conn_prop_name = "power_vdd3i";
integer inh_conn_def_value = "cds_globals.\\vdd3i! "; *)
\vdd3i! ;
wire (*
integer inh_conn_prop_name = "ground_gnd3i";
integer inh_conn_def_value = "cds_globals.\\gnd3i! "; *)
\gnd3i! ;
wire net9;
invrji3v #(.GT_PDL(3.5e-07), .GT_PUW(9e-07), .GT_PDW(4.2e-07), .GT_PUL(3e-07)) invr_1 (.out( net9 ), .in( A ));
invrji3v #(.GT_PDL(3.5e-07), .GT_PUW(1.12e-06), .GT_PDW(4.2e-07), .GT_PUL(3e-07)) invr_2 (.out( Q ), .in( net9 ));

endmodule
// Library - D_CELLS_JI3V, Cell - DFRQJI3VX4, View - cmos_sch
// LAST TIME SAVED: Mar 20 08:58:50 2023
// NETLIST TIME: Feb 12 01:23:42 2024

`worklib D_CELLS_JI3V
`view cmos_sch

`timescale 1ns / 1ps
(* cds_ams_schematic *)

module DFRQJI3VX4 (Q, C, D);
output  Q;
input  C, D;
wire (*
integer inh_conn_prop_name = "power_vdd3i";
integer inh_conn_def_value = "cds_globals.\\vdd3i! "; *)
\vdd3i! ;
wire (*
integer inh_conn_prop_name = "ground_gnd3i";
integer inh_conn_def_value = "cds_globals.\\gnd3i! "; *)
\gnd3i! ;
wire SQIB;
wire CIB;
wire CI;
invrji3v #(.GT_PDL(3.5e-07), .GT_PUW(5.64e-06), .GT_PDW(3.56e-06), .GT_PUL(3e-07)) invr_3 (.in( SQIB ), .out( Q ));
invrji3v #(.GT_PDL(3.5e-07), .GT_PUW(7.2e-07), .GT_PDW(4.2e-07), .GT_PUL(3e-07)) invr_2 (.out( CI ), .in( CIB ));
invrji3v #(.GT_PDL(3.5e-07), .GT_PUW(7.2e-07), .GT_PDW(4.2e-07), .GT_PUL(3e-07)) invr_1 (.out( CIB ), .in( C ));
pe3i #(.w(1.1e-06), .l(3e-07), .as(5.28e-13), .ad(5.28e-13), .ps(3.16e-06), .pd(3.16e-06), .nrs(0.245455), .nrd(0.245455), .m((1)*(1)), .par1((1)*(1)))
(* integer passed_mfactor = "m"; *)
 M24 (MQIB, CI, net162, \vdd3i! );
pe3i #(.w(1.11e-06), .l(3e-07), .as(5.328e-13), .ad(5.328e-13), .ps(3.18e-06), .pd(3.18e-06), .nrs(0.243243), .nrd(0.243243), .m((1)*(1)), .par1((1)*(1)))
(* integer passed_mfactor = "m"; *)
 M56 (MQI, MQIB, \vdd3i! , \vdd3i! );
pe3i #(.w(1.15e-06), .l(3e-07), .as(5.52e-13), .ad(5.52e-13), .ps(3.26e-06), .pd(3.26e-06), .nrs(0.234783), .nrd(0.234783), .m((1)*(1)), .par1((1)*(1)))
(* integer passed_mfactor = "m"; *)
 M30 (net170, MQI, \vdd3i! , \vdd3i! );
pe3i #(.w(1.1e-06), .l(3e-07), .as(5.28e-13), .ad(5.28e-13), .ps(3.16e-06), .pd(3.16e-06), .nrs(0.245455), .nrd(0.245455), .m((1)*(1)), .par1((1)*(1)))
(* integer passed_mfactor = "m"; *)
 M23 (net162, D, \vdd3i! , \vdd3i! );
pe3i #(.w(1.41e-06), .l(3e-07), .as(6.768e-13), .ad(6.768e-13), .ps(3.78e-06), .pd(3.78e-06), .nrs(0.191489), .nrd(0.191489), .m((1)*(1)), .par1((1)*(1)))
(* integer passed_mfactor = "m"; *)
 M59 (net142, SQIB, \vdd3i! , \vdd3i! );
pe3i #(.w(4.2e-07), .l(3e-07), .as(2.016e-13), .ad(2.016e-13), .ps(1.8e-06), .pd(1.8e-06), .nrs(0.642857), .nrd(0.642857), .m((1)*(1)), .par1((1)*(1)))
(* integer passed_mfactor = "m"; *)
 M36 (net166, net142, \vdd3i! , \vdd3i! );
pe3i #(.w(4.2e-07), .l(3e-07), .as(2.016e-13), .ad(2.016e-13), .ps(1.8e-06), .pd(1.8e-06), .nrs(0.642857), .nrd(0.642857), .m((1)*(1)), .par1((1)*(1)))
(* integer passed_mfactor = "m"; *)
 M35 (SQIB, CI, net166, \vdd3i! );
pe3i #(.w(4.2e-07), .l(3e-07), .as(2.016e-13), .ad(2.016e-13), .ps(1.8e-06), .pd(1.8e-06), .nrs(0.642857), .nrd(0.642857), .m((1)*(1)), .par1((1)*(1)))
(* integer passed_mfactor = "m"; *)
 M34 (MQIB, CIB, net174, \vdd3i! );
pe3i #(.w(1.15e-06), .l(3e-07), .as(5.52e-13), .ad(5.52e-13), .ps(3.26e-06), .pd(3.26e-06), .nrs(0.234783), .nrd(0.234783), .m((1)*(1)), .par1((1)*(1)))
(* integer passed_mfactor = "m"; *)
 M33 (SQIB, CIB, net170, \vdd3i! );
pe3i #(.w(4.2e-07), .l(3e-07), .as(2.016e-13), .ad(2.016e-13), .ps(1.8e-06), .pd(1.8e-06), .nrs(0.642857), .nrd(0.642857), .m((1)*(1)), .par1((1)*(1)))
(* integer passed_mfactor = "m"; *)
 M28 (net174, MQI, \vdd3i! , \vdd3i! );
ne3i #(.w(7e-07), .l(3.5e-07), .as(3.36e-13), .ad(3.36e-13), .ps(2.36e-06), .pd(2.36e-06), .nrs(0.385714), .nrd(0.385714), .m((1)*(1)), .par1((1)*(1)))
(* integer passed_mfactor = "m"; *)
 M18 (MQIB, CIB, net124, \gnd3i! );
ne3i #(.w(7.6e-07), .l(3.5e-07), .as(3.648e-13), .ad(3.648e-13), .ps(2.48e-06), .pd(2.48e-06), .nrs(0.355263), .nrd(0.355263), .m((1)*(1)), .par1((1)*(1)))
(* integer passed_mfactor = "m"; *)
 M17 (MQI, MQIB, \gnd3i! , \gnd3i! );
ne3i #(.w(7e-07), .l(3.5e-07), .as(3.36e-13), .ad(3.36e-13), .ps(2.36e-06), .pd(2.36e-06), .nrs(0.385714), .nrd(0.385714), .m((1)*(1)), .par1((1)*(1)))
(* integer passed_mfactor = "m"; *)
 M15 (net124, D, \gnd3i! , \gnd3i! );
ne3i #(.w(7.2e-07), .l(3.5e-07), .as(3.456e-13), .ad(3.456e-13), .ps(2.4e-06), .pd(2.4e-06), .nrs(0.375), .nrd(0.375), .m((1)*(1)), .par1((1)*(1)))
(* integer passed_mfactor = "m"; *)
 M46 (SQIB, CI, net132, \gnd3i! );
ne3i #(.w(4.2e-07), .l(3.5e-07), .as(2.016e-13), .ad(2.016e-13), .ps(1.8e-06), .pd(1.8e-06), .nrs(0.642857), .nrd(0.642857), .m((1)*(1)), .par1((1)*(1)))
(* integer passed_mfactor = "m"; *)
 M19 (MQIB, CI, net120, \gnd3i! );
ne3i #(.w(4.2e-07), .l(3.5e-07), .as(2.016e-13), .ad(2.016e-13), .ps(1.8e-06), .pd(1.8e-06), .nrs(0.642857), .nrd(0.642857), .m((1)*(1)), .par1((1)*(1)))
(* integer passed_mfactor = "m"; *)
 M51 (SQIB, CIB, net140, \gnd3i! );
ne3i #(.w(4.2e-07), .l(3.5e-07), .as(2.016e-13), .ad(2.016e-13), .ps(1.8e-06), .pd(1.8e-06), .nrs(0.642857), .nrd(0.642857), .m((1)*(1)), .par1((1)*(1)))
(* integer passed_mfactor = "m"; *)
 M50 (net140, net142, \gnd3i! , \gnd3i! );
ne3i #(.w(6.6e-07), .l(3.5e-07), .as(3.168e-13), .ad(3.168e-13), .ps(2.28e-06), .pd(2.28e-06), .nrs(0.409091), .nrd(0.409091), .m((1)*(1)), .par1((1)*(1)))
(* integer passed_mfactor = "m"; *)
 M49 (net142, SQIB, \gnd3i! , \gnd3i! );
ne3i #(.w(7.2e-07), .l(3.5e-07), .as(3.456e-13), .ad(3.456e-13), .ps(2.4e-06), .pd(2.4e-06), .nrs(0.375), .nrd(0.375), .m((1)*(1)), .par1((1)*(1)))
(* integer passed_mfactor = "m"; *)
 M47 (net132, MQI, \gnd3i! , \gnd3i! );
ne3i #(.w(4.2e-07), .l(3.5e-07), .as(2.016e-13), .ad(2.016e-13), .ps(1.8e-06), .pd(1.8e-06), .nrs(0.642857), .nrd(0.642857), .m((1)*(1)), .par1((1)*(1)))
(* integer passed_mfactor = "m"; *)
 M61 (net120, MQI, \gnd3i! , \gnd3i! );

endmodule
// Library - D_CELLS_JI3V, Cell - NA2JI3VX0, View - cmos_sch
// LAST TIME SAVED: Mar 20 08:58:34 2023
// NETLIST TIME: Feb 12 01:23:42 2024

`worklib D_CELLS_JI3V
`view cmos_sch

`timescale 1ns / 1ps
(* cds_ams_schematic *)

module NA2JI3VX0 (Q, A, B);
output  Q;
input  A, B;
wire (*
integer inh_conn_prop_name = "power_vdd3i";
integer inh_conn_def_value = "cds_globals.\\vdd3i! "; *)
\vdd3i! ;
wire (*
integer inh_conn_prop_name = "ground_gnd3i";
integer inh_conn_def_value = "cds_globals.\\gnd3i! "; *)
\gnd3i! ;
nand2ji3v #(.GT_PDL(3.5e-07), .GT_PUW(7e-07), .GT_PDW(5.6e-07), .GT_PUL(3e-07)) nand2_1 (.a( A ), .b( B ), .out( Q ));

endmodule
// Library - D_CELLS_JI3V, Cell - INJI3VX0, View - cmos_sch
// LAST TIME SAVED: Mar 20 08:58:38 2023
// NETLIST TIME: Feb 12 01:23:42 2024

`worklib D_CELLS_JI3V
`view cmos_sch

`timescale 1ns / 1ps
(* cds_ams_schematic *)

module INJI3VX0 (Q, A);
output  Q;
input  A;
wire (*
integer inh_conn_prop_name = "power_vdd3i";
integer inh_conn_def_value = "cds_globals.\\vdd3i! "; *)
\vdd3i! ;
wire (*
integer inh_conn_prop_name = "ground_gnd3i";
integer inh_conn_def_value = "cds_globals.\\gnd3i! "; *)
\gnd3i! ;
invrji3v #(.GT_PDL(3.5e-07), .GT_PUW(9.4e-07), .GT_PDW(4.2e-07), .GT_PUL(3e-07)) invr_1 (.out( Q ), .in( A ));

endmodule
// Library - D_CELLS_JI3V, Cell - DLY2JI3VX1, View - cmos_sch
// LAST TIME SAVED: Mar 20 08:58:47 2023
// NETLIST TIME: Feb 12 01:23:42 2024

`worklib D_CELLS_JI3V
`view cmos_sch

`timescale 1ns / 1ps
(* cds_ams_schematic *)

module DLY2JI3VX1 (Q, A);
output  Q;
input  A;
wire (*
integer inh_conn_prop_name = "power_vdd3i";
integer inh_conn_def_value = "cds_globals.\\vdd3i! "; *)
\vdd3i! ;
wire (*
integer inh_conn_prop_name = "ground_gnd3i";
integer inh_conn_def_value = "cds_globals.\\gnd3i! "; *)
\gnd3i! ;
wire net35;
wire net47;
invrji3v #(.GT_PDL(3.5e-07), .GT_PUW(1.41e-06), .GT_PDW(8.9e-07), .GT_PUL(3e-07)) invr_2 (.out( Q ), .in( net35 ));
invrji3v #(.GT_PDL(3.5e-07), .GT_PUW(7e-07), .GT_PDW(4.2e-07), .GT_PUL(3e-07)) invr_1 (.out( net47 ), .in( A ));
pe3i #(.w(4.2e-07), .l(1e-06), .as(2.016e-13), .ad(2.016e-13), .ps(1.8e-06), .pd(1.8e-06), .nrs(0.642857), .nrd(0.642857), .m((1)*(1)), .par1((1)*(1)))
(* integer passed_mfactor = "m"; *)
 M5 (net080, net039, \vdd3i! , \vdd3i! );
pe3i #(.w(4.2e-07), .l(7.4e-07), .as(2.016e-13), .ad(2.016e-13), .ps(1.8e-06), .pd(1.8e-06), .nrs(0.642857), .nrd(0.642857), .m((1)*(1)), .par1((1)*(1)))
(* integer passed_mfactor = "m"; *)
 M2 (net039, net47, net084, \vdd3i! );
pe3i #(.w(4.2e-07), .l(1e-06), .as(2.016e-13), .ad(2.016e-13), .ps(1.8e-06), .pd(1.8e-06), .nrs(0.642857), .nrd(0.642857), .m((1)*(1)), .par1((1)*(1)))
(* integer passed_mfactor = "m"; *)
 M6 (net35, net039, net080, \vdd3i! );
pe3i #(.w(4.2e-07), .l(7.4e-07), .as(2.016e-13), .ad(2.016e-13), .ps(1.8e-06), .pd(1.8e-06), .nrs(0.642857), .nrd(0.642857), .m((1)*(1)), .par1((1)*(1)))
(* integer passed_mfactor = "m"; *)
 M1 (net084, net47, \vdd3i! , \vdd3i! );
ne3i #(.w(4.2e-07), .l(8e-07), .as(2.016e-13), .ad(2.016e-13), .ps(1.8e-06), .pd(1.8e-06), .nrs(0.642857), .nrd(0.642857), .m((1)*(1)), .par1((1)*(1)))
(* integer passed_mfactor = "m"; *)
 M4 (net31, net47, \gnd3i! , \gnd3i! );
ne3i #(.w(4.2e-07), .l(1e-06), .as(2.016e-13), .ad(2.016e-13), .ps(1.8e-06), .pd(1.8e-06), .nrs(0.642857), .nrd(0.642857), .m((1)*(1)), .par1((1)*(1)))
(* integer passed_mfactor = "m"; *)
 M8 (net035, net039, \gnd3i! , \gnd3i! );
ne3i #(.w(4.2e-07), .l(1e-06), .as(2.016e-13), .ad(2.016e-13), .ps(1.8e-06), .pd(1.8e-06), .nrs(0.642857), .nrd(0.642857), .m((1)*(1)), .par1((1)*(1)))
(* integer passed_mfactor = "m"; *)
 M7 (net35, net039, net035, \gnd3i! );
ne3i #(.w(4.2e-07), .l(8e-07), .as(2.016e-13), .ad(2.016e-13), .ps(1.8e-06), .pd(1.8e-06), .nrs(0.642857), .nrd(0.642857), .m((1)*(1)), .par1((1)*(1)))
(* integer passed_mfactor = "m"; *)
 M3 (net039, net47, net31, \gnd3i! );

endmodule
// Library - D_CELLS_JI3V, Cell - BUJI3VX2, View - cmos_sch
// LAST TIME SAVED: Mar 20 08:58:52 2023
// NETLIST TIME: Feb 12 01:23:42 2024

`worklib D_CELLS_JI3V
`view cmos_sch

`timescale 1ns / 1ps
(* cds_ams_schematic *)

module BUJI3VX2 (Q, A);
output  Q;
input  A;
wire (*
integer inh_conn_prop_name = "power_vdd3i";
integer inh_conn_def_value = "cds_globals.\\vdd3i! "; *)
\vdd3i! ;
wire (*
integer inh_conn_prop_name = "ground_gnd3i";
integer inh_conn_def_value = "cds_globals.\\gnd3i! "; *)
\gnd3i! ;
wire net9;
invrji3v #(.GT_PDL(3.5e-07), .GT_PUW(1.1e-06), .GT_PDW(6e-07), .GT_PUL(3e-07)) invr_1 (.out( net9 ), .in( A ));
invrji3v #(.GT_PDL(3.5e-07), .GT_PUW(2.92e-06), .GT_PDW(1.2e-06), .GT_PUL(3e-07)) invr_2 (.out( Q ), .in( net9 ));

endmodule
// Library - D_CELLS_JI3V, Cell - DECAP5JI3V, View - cmos_sch
// LAST TIME SAVED: Mar 20 08:58:51 2023
// NETLIST TIME: Feb 12 01:23:42 2024

`worklib D_CELLS_JI3V
`view cmos_sch

`timescale 1ns / 1ps
(* cds_ams_schematic *)

module DECAP5JI3V ( );
wire (*
integer inh_conn_prop_name = "power_vdd3i";
integer inh_conn_def_value = "cds_globals.\\vdd3i! "; *)
\vdd3i! ;
wire (*
integer inh_conn_prop_name = "ground_gnd3i";
integer inh_conn_def_value = "cds_globals.\\gnd3i! "; *)
\gnd3i! ;
ne3i #(.w(8.3e-07), .l(1.48e-06), .as(3.984e-13), .ad(3.984e-13), .ps(2.62e-06), .pd(2.62e-06), .nrs(0.325301), .nrd(0.325301), .m((1)*(1)), .par1((1)*(1)))
(* integer passed_mfactor = "m"; *)
 M0 (net5, net4, \gnd3i! , \gnd3i! );
pe3i #(.w(1.36e-06), .l(1.46e-06), .as(6.528e-13), .ad(6.528e-13), .ps(3.68e-06), .pd(3.68e-06), .nrs(0.198529), .nrd(0.198529), .m((1)*(1)), .par1((1)*(1)))
(* integer passed_mfactor = "m"; *)
 M1 (net4, net5, \vdd3i! , \vdd3i! );

endmodule
// Library - D_CELLS_JI3V, Cell - DECAP7JI3V, View - cmos_sch
// LAST TIME SAVED: Mar 20 08:58:51 2023
// NETLIST TIME: Feb 12 01:23:42 2024

`worklib D_CELLS_JI3V
`view cmos_sch

`timescale 1ns / 1ps
(* cds_ams_schematic *)

module DECAP7JI3V ( );
wire (*
integer inh_conn_prop_name = "power_vdd3i";
integer inh_conn_def_value = "cds_globals.\\vdd3i! "; *)
\vdd3i! ;
wire (*
integer inh_conn_prop_name = "ground_gnd3i";
integer inh_conn_def_value = "cds_globals.\\gnd3i! "; *)
\gnd3i! ;
ne3i #(.w(8.8e-07), .l(3.5e-07), .as(4.224e-13), .ad(4.224e-13), .ps(2.72e-06), .pd(2.72e-06), .nrs(0.306818), .nrd(0.306818), .m((1)*(1)), .par1((1)*(1)))
(* integer passed_mfactor = "m"; *)
 M7 (net3, net4, \gnd3i! , \gnd3i! );
ne3i #(.w(8.8e-07), .l(1.75e-06), .as(4.224e-13), .ad(4.224e-13), .ps(2.72e-06), .pd(2.72e-06), .nrs(0.306818), .nrd(0.306818), .m((1)*(1)), .par1((1)*(1)))
(* integer passed_mfactor = "m"; *)
 M6 (\gnd3i! , net4, \gnd3i! , \gnd3i! );
pe3i #(.w(1.315e-06), .l(3e-07), .as(6.312e-13), .ad(6.312e-13), .ps(3.59e-06), .pd(3.59e-06), .nrs(0.205323), .nrd(0.205323), .m((1)*(1)), .par1((1)*(1)))
(* integer passed_mfactor = "m"; *)
 M5 (net4, net3, \vdd3i! , \vdd3i! );
pe3i #(.w(1.315e-06), .l(1.71e-06), .as(6.312e-13), .ad(6.312e-13), .ps(3.59e-06), .pd(3.59e-06), .nrs(0.205323), .nrd(0.205323), .m((1)*(1)), .par1((1)*(1)))
(* integer passed_mfactor = "m"; *)
 M4 (\vdd3i! , net3, \vdd3i! , \vdd3i! );

endmodule
// Library - INV_HV, Cell - inv_hv, View - schematic
// LAST TIME SAVED: Feb  5 02:38:24 2024
// NETLIST TIME: Feb 12 01:23:42 2024

`worklib INV_HV
`view schematic

`timescale 1ns / 1ps
(* cds_ams_schematic *)

module inv_hv (GNDHV, IN, OUT, VDDHV, VSUB);
inout  GNDHV, IN, OUT, VDDHV, VSUB;
nedia #(.w(4e-05), .l(1.25e-06), .m((1)*(1)), .par1((1)*(1)), .extlay(0), .xf_subext(0))
(* integer passed_mfactor = "m"; *)
 M0 (OUT, IN, GNDHV, VSUB);
rpp1k1_3 #(.l(0.000103425), .w(1e-05), .m(1), .par1(1))
(* integer passed_mfactor = "m"; *)
 R0 (VDDHV, OUT, VSUB);

endmodule
// Library - TOP, Cell - top, View - schematic
// LAST TIME SAVED: Feb 12 01:22:56 2024
// NETLIST TIME: Feb 12 01:23:42 2024

`worklib TOP
`view schematic

`timescale 1ns / 1ps
(* cds_ams_schematic *)

module top (CLK, ENABLE, GNDA, GNDD, GNDHV, GNDOHV, GNDOR, GNDORA, INL, OUT0, OUT1, OUT2, OUTHV, OUTL, PSUB, RESET, VDDA, VDDD, VDDHV, VDDOR, VDDORA);
inout  CLK, ENABLE, GNDA, GNDD, GNDHV, GNDOHV, GNDOR, GNDORA, INL, OUT0, OUT1, OUT2, OUTHV, OUTL, PSUB, RESET, VDDA, VDDD, VDDHV, VDDOR, VDDORA;
wire [7:0] out;
wire enable;
wire clk;
wire reset;
inv I1 (.VS( GNDA ), .VD( VDDA ), .OUT( OUTL ), .IN( INL ));
inv_hv I2 (.GNDHV( GNDHV ), .VSUB( PSUB ), .VDDHV( VDDHV ), .OUT( OUTHV ), .IN( out[2] ));
counter (*  integer cds_net_set [0:1] = { "power_vdd3i","ground_gnd3i" }; integer power_vdd3i = "VDDD"; integer ground_gnd3i = "GNDD";  *)  I3 (.out( out[7:0] ), .reset( reset ), .clk( clk ), .enable( enable ));
ioring3 I0 (.GNDA( GNDA ), .GNDD( GNDD ), .GNDHV( GNDHV ), .GNDOHV( GNDOHV ), .GNDOR( GNDOR ), .GNDORA( GNDORA ), .VDDA( VDDA ), .VDDD( VDDD ), .VDDHV( VDDHV ), .VDDOR( VDDOR ), .VDDORA( VDDORA ), .reset_core( reset ), .out2_core( out[2] ), .out1_core( out[1] ), .out0_core( out[0] ), .inl_core( INL ), .enable_core( enable ), .clk_core( clk ), .ENABLE( ENABLE ), .CLK( CLK ), .RESET( RESET ), .PSUB( PSUB ), .OUTL( OUTL ), .OUTHV( OUTHV ), .OUT2( OUT2 ), .OUT1( OUT1 ), .OUT0( OUT0 ), .INL( INL ));

endmodule
// Library - TOP, Cell - top_tb, View - schematic
// LAST TIME SAVED: Feb 12 01:22:48 2024
// NETLIST TIME: Feb 12 01:23:42 2024

`worklib TOP
`view schematic

`timescale 1ns / 1ps
(* cds_ams_schematic *)

module top_tb ( );
wire clk;
wire enable;
wire in_l;
wire reset;
wire out0;
wire out1;
wire out2;
wire out_h;
wire out_l;
wire VDDHV;
wire VDDD;
wire VDDA;
wire net7;
wire net12;
wire net8;
wire net15;
wire net17;
wire net9;
wire net13;
top I0 (.GNDA( net13 ), .GNDD( net9 ), .GNDHV( net17 ), .GNDOHV( net15 ), .GNDOR( net8 ), .GNDORA( net12 ), .PSUB( net7 ), .VDDA( VDDA ), .VDDD( VDDD ), .VDDHV( VDDHV ), .VDDOR( VDDD ), .VDDORA( VDDA ), .OUTL( out_l ), .OUTHV( out_h ), .OUT2( out2 ), .OUT1( out1 ), .OUT0( out0 ), .RESET( reset ), .INL( in_l ), .ENABLE( enable ), .CLK( clk ));
counter_stimulus I1 (.clk( clk ), .enable( enable ), .reset( reset ));
vsource #(.dc(0), .type("dc")) V9 (net16, cds_globals.\gnd! );
vsource #(.dc(0), .type("dc")) V8 (net14, cds_globals.\gnd! );
vsource #(.dc(0), .type("dc")) V7 (net11, cds_globals.\gnd! );
vsource #(.dc(0), .type("dc")) V6 (net10, cds_globals.\gnd! );
vsource #(.dc(0), .type("dc")) V5 (net6, cds_globals.\gnd! );
vsource #(.dc(0), .type("dc")) V4 (net5, cds_globals.\gnd! );
vsource #(.dc(0), .type("dc")) V3 (net4, cds_globals.\gnd! );
vsource #(.dc(40), .type("dc")) V2 (net3, cds_globals.\gnd! );
vsource #(.dc(3.3), .type("dc")) V1 (net2, cds_globals.\gnd! );
vsource #(.dc(3.3), .type("dc")) V0 (net1, cds_globals.\gnd! );
resistor #(.r(0.1)) R9 (net17, net16);
resistor #(.r(0.1)) R8 (net15, net14);
resistor #(.r(0.1)) R7 (net13, net11);
resistor #(.r(0.1)) R6 (net12, net10);
resistor #(.r(0.1)) R5 (net9, net6);
resistor #(.r(0.1)) R4 (net8, net5);
resistor #(.r(0.1)) R3 (net7, net4);
resistor #(.r(0.1)) R2 (VDDHV, net3);
resistor #(.r(0.1)) R1 (VDDA, net2);
resistor #(.r(0.1)) R0 (VDDD, net1);
vsource #(.type("pulse"), .val0(0), .val1(3.3), .period(1e-07), .delay(1e-08), .rise(1e-09), .fall(1e-09), .width(5e-08)) V10 (in_l, cds_globals.\gnd! );

endmodule
`noworklib
`noview
