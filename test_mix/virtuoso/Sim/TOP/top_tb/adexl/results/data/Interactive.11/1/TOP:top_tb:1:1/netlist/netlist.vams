// AMS netlist generated by the AMS Unified netlister
// IC subversion:  IC6.1.8-64b.500.34
// Xcelium version: 23.09-s002
// Copyright(C) 2005-2009, Cadence Design Systems, Inc
// User: saul Pid: 13842
// Design library name: TOP
// Design cell name: top_tb
// Design view name: config_sch
// Solver: Spectre

`include "disciplines.vams"
`include "userDisciplines.vams"
// HDL file - COUNTER_JI3, counter_stimulus, verilogams.
// HDL file - COUNTER_JI3, counter, functional.
// Library - IO_CELLS_JIC3V, Cell - jio_ne3i_pc, View - cmos_sch
// LAST TIME SAVED: Nov 16 11:08:58 2021
// NETLIST TIME: Feb  9 05:16:35 2024

`worklib IO_CELLS_JIC3V
`view cmos_sch

`timescale 1ns / 1ps
(* cds_ams_schematic *)

module jio_ne3i_pc (B, D, G, S);
inout  B, D, G, S;
dn3 #(.area(9.9e-12), .perimeter(6.6e-07), .dbv(0), .m(1), .par1(1), .xf_subext(0))
(* integer passed_mfactor = "m"; *)
 D3 (B, D);
rdn3 #(.l(3.35e-06), .w(3e-05), .m(1), .par1(1), .xf_subext(0))
(* integer passed_mfactor = "m"; *)
 R0 (D, net6, B);
ne3i #(.w(3e-05), .l(4e-07), .as(1.44e-11), .ad(1.44e-11), .ps(6.096e-05), .pd(6.096e-05), .nrs(0.009), .nrd(0.009), .m((1)*(1)), .par1((1)*(1)))
(* integer passed_mfactor = "m"; *)
 M0 (net6, G, S, B);

endmodule
// Library - IO_CELLS_JIC3V, Cell - jio_andio_pc, View - cmos_sch
// LAST TIME SAVED: Nov 16 02:00:22 2021
// NETLIST TIME: Feb  9 05:16:35 2024

`worklib IO_CELLS_JIC3V
`view cmos_sch

`timescale 1ns / 1ps
(* cds_ams_schematic *)

module jio_andio_pc (DNW, PSUB, PWI);
input  DNW, PSUB, PWI;
ddnwmv #(.area(4.69976e-09), .perimeter(0.00027464), .dbv(0), .m(1), .par1(1), .xf_subext(0))
(* integer passed_mfactor = "m"; *)
 D3 (PSUB, DNW);
dipdnwmv #(.area(4.16648e-09), .perimeter(0.00025864), .dbv(0), .m(1), .par1(1))
(* integer passed_mfactor = "m"; *)
 D1 (PWI, DNW);

endmodule
// Library - IO_CELLS_JIC3V, Cell - jio_opdio_pc, View - cmos_sch
// LAST TIME SAVED: Nov 16 02:00:11 2021
// NETLIST TIME: Feb  9 05:16:35 2024

`worklib IO_CELLS_JIC3V
`view cmos_sch

`timescale 1ns / 1ps
(* cds_ams_schematic *)

module jio_opdio_pc (DNLW, DNW, LPWI, NW, PSUB, PWI, VDN);
input  DNLW, DNW, LPWI, NW, PSUB, PWI, VDN;
jio_lviodio_pc I5 (.PSUB( PSUB ), .DNLW( DNLW ), .LPWI( LPWI ));
jio_andio_pc I0 (.DNW( VDN ), .PWI( PWI ), .PSUB( PSUB ));
ddnwmv #(.area(5.2955e-10), .perimeter(0.00010026), .dbv(0), .m(1), .par1(1), .xf_subext(0))
(* integer passed_mfactor = "m"; *)
 D0 (PSUB, DNW);
dipdnwmv #(.area(2.1664e-10), .perimeter(5.908e-05), .dbv(0), .m(1), .par1(1))
(* integer passed_mfactor = "m"; *)
 D1 (PWI, NW);
dipdnwmv #(.area(2.1664e-10), .perimeter(5.908e-05), .dbv(0), .m(1), .par1(1))
(* integer passed_mfactor = "m"; *)
 D3 (PWI, NW);
dipdnwmv #(.area(1.9592e-10), .perimeter(7.464e-05), .dbv(0), .m(1), .par1(1))
(* integer passed_mfactor = "m"; *)
 D5 (PWI, DNW);

endmodule
// Library - IO_CELLS_JIC3V, Cell - jio_ndtr_pc, View - cmos_sch
// LAST TIME SAVED: Nov 16 02:00:18 2021
// NETLIST TIME: Feb  9 05:16:35 2024

`worklib IO_CELLS_JIC3V
`view cmos_sch

`timescale 1ns / 1ps
(* cds_ams_schematic *)

module jio_ndtr_pc (PO, Y, GND, GNDR, PI, VDD, VDDR, YN);
output  PO, Y;
input  GND, GNDR, PI, VDD, VDDR, YN;
pe3i #(.w(2.4e-06), .l(3.5e-07), .as(1.152e-12), .ad(6.48e-13), .ps(5.76e-06), .pd(2.94e-06), .nrs(0.1125), .nrd(0.1125), .m((1)*(2)), .par1((1)*(2)))
(* integer passed_mfactor = "m"; *)
 M1 (net14, YN, VDD, VDD);
pe3i #(.w(2.4e-06), .l(3.5e-07), .as(8.16e-13), .ad(6.48e-13), .ps(3.88e-06), .pd(2.94e-06), .nrs(0.1125), .nrd(0.1125), .m((1)*(6)), .par1((1)*(6)))
(* integer passed_mfactor = "m"; *)
 M3 (net19, net14, VDD, VDD);
pe3i #(.w(2.4e-06), .l(3.5e-07), .as(1.152e-12), .ad(1.152e-12), .ps(5.76e-06), .pd(5.76e-06), .nrs(0.1125), .nrd(0.1125), .m((1)*(1)), .par1((1)*(1)))
(* integer passed_mfactor = "m"; *)
 M7 (PO, PI, VDD, VDD);
pe3i #(.w(2.4e-06), .l(3.5e-07), .as(1.152e-12), .ad(1.152e-12), .ps(5.76e-06), .pd(5.76e-06), .nrs(0.1125), .nrd(0.1125), .m((1)*(1)), .par1((1)*(1)))
(* integer passed_mfactor = "m"; *)
 M9 (PO, net14, VDD, VDD);
pe3i #(.w(2.4e-06), .l(3.5e-07), .as(1.152e-12), .ad(6.48e-13), .ps(5.76e-06), .pd(2.94e-06), .nrs(0.1125), .nrd(0.1125), .m((1)*(2)), .par1((1)*(2)))
(* integer passed_mfactor = "m"; *)
 M11 (net16, net14, VDD, VDD);
pe3i #(.w(2.4e-06), .l(3.5e-07), .as(7.488e-13), .ad(6.48e-13), .ps(3.504e-06), .pd(2.94e-06), .nrs(0.1125), .nrd(0.1125), .m((1)*(10)), .par1((1)*(10)))
(* integer passed_mfactor = "m"; *)
 M5 (Y, net19, VDD, VDD);
ne3i #(.w(1.2e-06), .l(4e-07), .as(5.76e-13), .ad(3.24e-13), .ps(3.36e-06), .pd(1.74e-06), .nrs(0.225), .nrd(0.225), .m((1)*(2)), .par1((1)*(2)))
(* integer passed_mfactor = "m"; *)
 M2 (net14, YN, GND, GND);
ne3i #(.w(1.68e-06), .l(4e-07), .as(5.712e-13), .ad(4.536e-13), .ps(2.92e-06), .pd(2.22e-06), .nrs(0.160714), .nrd(0.160714), .m((1)*(6)), .par1((1)*(6)))
(* integer passed_mfactor = "m"; *)
 M6 (Y, net16, GND, GND);
ne3i #(.w(1.68e-06), .l(4e-07), .as(8.064e-13), .ad(8.064e-13), .ps(4.32e-06), .pd(4.32e-06), .nrs(0.160714), .nrd(0.160714), .m((1)*(1)), .par1((1)*(1)))
(* integer passed_mfactor = "m"; *)
 M8 (PO, net14, net37, GND);
ne3i #(.w(1.68e-06), .l(4e-07), .as(8.064e-13), .ad(8.064e-13), .ps(4.32e-06), .pd(4.32e-06), .nrs(0.160714), .nrd(0.160714), .m((1)*(1)), .par1((1)*(1)))
(* integer passed_mfactor = "m"; *)
 M10 (net37, PI, GND, GND);
ne3i #(.w(1.68e-06), .l(4e-07), .as(8.064e-13), .ad(4.536e-13), .ps(4.32e-06), .pd(2.22e-06), .nrs(0.160714), .nrd(0.160714), .m((1)*(2)), .par1((1)*(2)))
(* integer passed_mfactor = "m"; *)
 M13 (net19, net14, GND, GND);
ne3i #(.w(1.68e-06), .l(4e-07), .as(6.3e-13), .ad(4.536e-13), .ps(3.27e-06), .pd(2.22e-06), .nrs(0.160714), .nrd(0.160714), .m((1)*(4)), .par1((1)*(4)))
(* integer passed_mfactor = "m"; *)
 M4 (net16, net14, GND, GND);

endmodule
// Library - IO_CELLS_JIC3V, Cell - jio_bufc_pc, View - cmos_sch
// LAST TIME SAVED: Nov 16 02:00:21 2021
// NETLIST TIME: Feb  9 05:16:35 2024

`worklib IO_CELLS_JIC3V
`view cmos_sch

`timescale 1ns / 1ps
(* cds_ams_schematic *)

module jio_bufc_pc (Y, A, GNDR, VDDR);
output  Y;
input  A, GNDR, VDDR;
ne3i #(.w(2e-06), .l(4e-07), .as(9.6e-13), .ad(9.6e-13), .ps(4.96e-06), .pd(4.96e-06), .nrs(0.135), .nrd(0.135), .m((1)*(3)), .par1((1)*(3)))
(* integer passed_mfactor = "m"; *)
 M2 (Y, A, GNDR, GNDR);
pe3i #(.w(2.2e-06), .l(3.5e-07), .as(9.6e-13), .ad(9.6e-13), .ps(4.96e-06), .pd(4.96e-06), .nrs(0.135), .nrd(0.135), .m((1)*(6)), .par1((1)*(6)))
(* integer passed_mfactor = "m"; *)
 M1 (Y, A, VDDR, VDDR);

endmodule
// Library - IO_CELLS_JIC3V, Cell - jio_resp_pc, View - cmos_sch
// LAST TIME SAVED: Nov 16 11:13:59 2021
// NETLIST TIME: Feb  9 05:16:35 2024

`worklib IO_CELLS_JIC3V
`view cmos_sch

`timescale 1ns / 1ps
(* cds_ams_schematic *)

module jio_resp_pc (RH, GNDO, VDDO);
output  RH;
input  GNDO, VDDO;
rdp3 #(.l(3.3e-06), .w(4.4e-07), .m(1), .par1(1))
(* integer passed_mfactor = "m"; *)
 R0 (VDDO, RH, VDDO);

endmodule
// Library - IO_CELLS_JIC3V, Cell - jio_ne3is_pc, View - cmos_sch
// LAST TIME SAVED: Nov 16 11:09:51 2021
// NETLIST TIME: Feb  9 05:16:35 2024

`worklib IO_CELLS_JIC3V
`view cmos_sch

`timescale 1ns / 1ps
(* cds_ams_schematic *)

module jio_ne3is_pc (B, D, G, S);
inout  B, D, G, S;
dn3 #(.area(3.96e-12), .perimeter(6.6e-07), .dbv(0), .m(1), .par1(1), .xf_subext(0))
(* integer passed_mfactor = "m"; *)
 D3 (B, D);
rdn3 #(.l(1.32e-06), .w(1.2e-05), .m(1), .par1(1), .xf_subext(0))
(* integer passed_mfactor = "m"; *)
 R4 (D, net6, B);
ne3i #(.w(1.2e-05), .l(4e-07), .as(5.76e-12), .ad(5.76e-12), .ps(2.496e-05), .pd(2.496e-05), .nrs(0.0225), .nrd(0.0225), .m((1)*(1)), .par1((1)*(1)))
(* integer passed_mfactor = "m"; *)
 M0 (net6, G, S, B);

endmodule
// Library - IO_CELLS_JIC3V, Cell - jio_esd1_pc, View - cmos_sch
// LAST TIME SAVED: Nov 16 11:06:13 2021
// NETLIST TIME: Feb  9 05:16:35 2024

`worklib IO_CELLS_JIC3V
`view cmos_sch

`timescale 1ns / 1ps
(* cds_ams_schematic *)

module jio_esd1_pc (Y, A, GNDO, GNDR, PSUB, VDDO, VDDR);
output  Y;
input  A, GNDO, GNDR, PSUB, VDDO, VDDR;
wire rh;
wire ng;
jio_resp_pc I3 (.RH( rh ), .VDDO( VDDO ), .GNDO( GNDO ));
jio_pe3i_pc IP_1 (.S( VDDO ), .G( rh ), .B( VDDO ), .D( A ));
jio_pe3i_pc IP_2 (.S( VDDO ), .G( rh ), .B( VDDO ), .D( A ));
jio_pe3i_pc IP_3 (.S( VDDO ), .G( rh ), .B( VDDO ), .D( A ));
jio_pe3i_pc IP_4 (.S( VDDO ), .G( rh ), .B( VDDO ), .D( A ));
jio_pe3i_pc IP_5 (.S( VDDO ), .G( rh ), .B( VDDO ), .D( A ));
jio_pe3i_pc IP_6 (.S( VDDO ), .G( rh ), .B( VDDO ), .D( A ));
jio_pe3i_pc IP_7 (.S( VDDO ), .G( rh ), .B( VDDO ), .D( A ));
jio_pe3i_pc IP_8 (.S( VDDO ), .G( rh ), .B( VDDO ), .D( A ));
jio_pe3i_pc IP_9 (.S( VDDO ), .G( rh ), .B( VDDO ), .D( A ));
jio_pe3i_pc IP_10 (.S( VDDO ), .G( rh ), .B( VDDO ), .D( A ));
jio_pe3i_pc IP_11 (.S( VDDO ), .G( rh ), .B( VDDO ), .D( A ));
jio_pe3i_pc IP_12 (.S( VDDO ), .G( rh ), .B( VDDO ), .D( A ));
jio_pe3i_pc IP_13 (.S( VDDO ), .G( rh ), .B( VDDO ), .D( A ));
jio_pe3i_pc IP_14 (.S( VDDO ), .G( rh ), .B( VDDO ), .D( A ));
jio_pe3i_pc IP_15 (.S( VDDO ), .G( rh ), .B( VDDO ), .D( A ));
jio_pe3i_pc IP_16 (.S( VDDO ), .G( rh ), .B( VDDO ), .D( A ));
jio_pe3i_pc IP_17 (.S( VDDO ), .G( rh ), .B( VDDO ), .D( A ));
jio_pe3i_pc IP_18 (.S( VDDO ), .G( rh ), .B( VDDO ), .D( A ));
jio_pe3i_pc IP_19 (.S( VDDO ), .G( rh ), .B( VDDO ), .D( A ));
jio_pe3i_pc IP_20 (.S( VDDO ), .G( rh ), .B( VDDO ), .D( A ));
jio_pe3i_pc IP_21 (.S( VDDO ), .G( rh ), .B( VDDO ), .D( A ));
jio_pe3i_pc IP_22 (.S( VDDO ), .G( rh ), .B( VDDO ), .D( A ));
jio_pe3i_pc IP_23 (.S( VDDO ), .G( rh ), .B( VDDO ), .D( A ));
jio_pe3i_pc IP_24 (.S( VDDO ), .G( rh ), .B( VDDO ), .D( A ));
jio_ne3i_pc IN_1 (.D( A ), .B( GNDO ), .G( ng ), .S( GNDO ));
jio_ne3i_pc IN_2 (.D( A ), .B( GNDO ), .G( ng ), .S( GNDO ));
jio_ne3i_pc IN_3 (.D( A ), .B( GNDO ), .G( ng ), .S( GNDO ));
jio_ne3i_pc IN_4 (.D( A ), .B( GNDO ), .G( ng ), .S( GNDO ));
jio_ne3i_pc IN_5 (.D( A ), .B( GNDO ), .G( ng ), .S( GNDO ));
jio_ne3i_pc IN_6 (.D( A ), .B( GNDO ), .G( ng ), .S( GNDO ));
jio_ne3i_pc IN_7 (.D( A ), .B( GNDO ), .G( ng ), .S( GNDO ));
jio_ne3i_pc IN_8 (.D( A ), .B( GNDO ), .G( ng ), .S( GNDO ));
jio_ne3i_pc IN_9 (.D( A ), .B( GNDO ), .G( ng ), .S( GNDO ));
jio_ne3i_pc IN_10 (.D( A ), .B( GNDO ), .G( ng ), .S( GNDO ));
jio_ne3i_pc IN_11 (.D( A ), .B( GNDO ), .G( ng ), .S( GNDO ));
jio_ne3i_pc IN_12 (.D( A ), .B( GNDO ), .G( ng ), .S( GNDO ));
jio_ne3i_pc IN_13 (.D( A ), .B( GNDO ), .G( ng ), .S( GNDO ));
jio_ne3i_pc IN_14 (.D( A ), .B( GNDO ), .G( ng ), .S( GNDO ));
jio_ne3i_pc IN_15 (.D( A ), .B( GNDO ), .G( ng ), .S( GNDO ));
jio_ne3i_pc IN_16 (.D( A ), .B( GNDO ), .G( ng ), .S( GNDO ));
jio_ne3i_pc IN_17 (.D( A ), .B( GNDO ), .G( ng ), .S( GNDO ));
jio_ne3i_pc IN_18 (.D( A ), .B( GNDO ), .G( ng ), .S( GNDO ));
jio_ne3i_pc IN_19 (.D( A ), .B( GNDO ), .G( ng ), .S( GNDO ));
jio_ne3i_pc IN_20 (.D( A ), .B( GNDO ), .G( ng ), .S( GNDO ));
jio_ne3i_pc IN_21 (.D( A ), .B( GNDO ), .G( ng ), .S( GNDO ));
jio_ne3i_pc IN_22 (.D( A ), .B( GNDO ), .G( ng ), .S( GNDO ));
jio_ne3i_pc IN_23 (.D( A ), .B( GNDO ), .G( ng ), .S( GNDO ));
jio_ne3i_pc IN_24 (.D( A ), .B( GNDO ), .G( ng ), .S( GNDO ));
jio_ne3is_pc INS_1 (.D( Y ), .B( GNDO ), .G( GNDO ), .S( GNDO ));
jio_ne3is_pc INS_2 (.D( Y ), .B( GNDO ), .G( GNDO ), .S( GNDO ));
pe3i #(.w(1.2e-05), .l(3.5e-07), .as(5.76e-12), .ad(3.24e-12), .ps(2.496e-05), .pd(1.254e-05), .nrs(0.0225), .nrd(0.0225), .m((1)*(2)), .par1((1)*(2)))
(* integer passed_mfactor = "m"; *)
 M3 (Y, VDDO, VDDO, VDDO);
rpp1 #(.l(4.5e-06), .w(2.5e-06), .m(1), .par1(1))
(* integer passed_mfactor = "m"; *)
 R1 (A, Y);
ne3i #(.w(1.2e-06), .l(4e-07), .as(5.76e-13), .ad(5.76e-13), .ps(3.36e-06), .pd(3.36e-06), .nrs(0.225), .nrd(0.225), .m((1)*(1)), .par1((1)*(1)))
(* integer passed_mfactor = "m"; *)
 M2 (ng, rh, GNDO, GNDO);

endmodule
// Library - IO_CELLS_JIC3V, Cell - ICPC, View - cmos_sch
// LAST TIME SAVED: Nov 16 02:00:25 2021
// NETLIST TIME: Feb  9 05:16:35 2024

`worklib IO_CELLS_JIC3V
`view cmos_sch

`timescale 1ns / 1ps
(* cds_ams_schematic *)

module ICPC (PO, Y, GNDI, GNDOI, GNDRI, PAD, PI, PSUB, VDD3I, VDDOI, VDDRI);
output  PO, Y;
input  GNDI, GNDOI, GNDRI, PAD, PI, PSUB, VDD3I, VDDOI, VDDRI;
wire net12;
wire net13;
jio_ipdio_pc I5 (.PSUB( PSUB ), .DNWR( VDDRI ), .PWIR( GNDRI ));
jio_opdio_pc I6 (.VDN( VDDOI ), .PSUB( PSUB ), .NW( VDDOI ), .DNLW( VDD3I ), .DNW( VDDOI ), .PWI( GNDOI ), .LPWI( GNDI ));
jio_ndtr_pc I4 (.YN( net12 ), .PI( PI ), .PO( PO ), .VDD( VDD3I ), .Y( Y ), .VDDR( VDDRI ), .GNDR( GNDRI ), .GND( GNDI ));
jio_bufc_pc I3 (.A( net13 ), .Y( net12 ), .VDDR( VDDRI ), .GNDR( GNDRI ));
jio_esd1_pc I1 (.Y( net13 ), .A( PAD ), .GNDO( GNDOI ), .VDDR( VDDRI ), .GNDR( GNDRI ), .VDDO( VDDOI ), .PSUB( PSUB ));

endmodule
// Library - IO_CELLS_JIC3V, Cell - PWRCUTDCPC, View - cmos_sch
// LAST TIME SAVED: Nov 16 02:00:24 2021
// NETLIST TIME: Feb  9 05:16:35 2024

`worklib IO_CELLS_JIC3V
`view cmos_sch

`timescale 1ns / 1ps
(* cds_ams_schematic *)

module PWRCUTDCPC (GNDI1, GNDI2, GNDOI1, GNDOI2, GNDRI1, GNDRI2, PSUB, VDD3I1, VDD3I2, VDDOI1, VDDOI2, VDDRI1, VDDRI2);
input  GNDI1, GNDI2, GNDOI1, GNDOI2, GNDRI1, GNDRI2, PSUB, VDD3I1, VDD3I2, VDDOI1, VDDOI2, VDDRI1, VDDRI2;
dp3 #(.area(5.91506e-11), .perimeter(6.486e-05), .dbv(0), .m(1), .par1(1))
(* integer passed_mfactor = "m"; *)
 D4_1 (GNDOI1, GNDOI2);
dp3 #(.area(5.91506e-11), .perimeter(6.486e-05), .dbv(0), .m(1), .par1(1))
(* integer passed_mfactor = "m"; *)
 D4_2 (GNDOI1, GNDOI2);
dp3 #(.area(5.91506e-11), .perimeter(6.486e-05), .dbv(0), .m(1), .par1(1))
(* integer passed_mfactor = "m"; *)
 D4_3 (GNDOI1, GNDOI2);
dp3 #(.area(5.91506e-11), .perimeter(6.486e-05), .dbv(0), .m(1), .par1(1))
(* integer passed_mfactor = "m"; *)
 D4_4 (GNDOI1, GNDOI2);
dp3 #(.area(5.91506e-11), .perimeter(6.486e-05), .dbv(0), .m(1), .par1(1))
(* integer passed_mfactor = "m"; *)
 D4_5 (GNDOI1, GNDOI2);
dp3 #(.area(5.91506e-11), .perimeter(6.486e-05), .dbv(0), .m(1), .par1(1))
(* integer passed_mfactor = "m"; *)
 D4_6 (GNDOI1, GNDOI2);
dp3 #(.area(5.91506e-11), .perimeter(6.486e-05), .dbv(0), .m(1), .par1(1))
(* integer passed_mfactor = "m"; *)
 D4_7 (GNDOI1, GNDOI2);
dp3 #(.area(5.91506e-11), .perimeter(6.486e-05), .dbv(0), .m(1), .par1(1))
(* integer passed_mfactor = "m"; *)
 D4_8 (GNDOI1, GNDOI2);
dp3 #(.area(5.91506e-11), .perimeter(6.486e-05), .dbv(0), .m(1), .par1(1))
(* integer passed_mfactor = "m"; *)
 D4_9 (GNDOI1, GNDOI2);
dp3 #(.area(5.91506e-11), .perimeter(6.486e-05), .dbv(0), .m(1), .par1(1))
(* integer passed_mfactor = "m"; *)
 D4_10 (GNDOI1, GNDOI2);
dp3 #(.area(5.91506e-11), .perimeter(6.486e-05), .dbv(0), .m(1), .par1(1))
(* integer passed_mfactor = "m"; *)
 D4_11 (GNDOI1, GNDOI2);
dp3 #(.area(5.91506e-11), .perimeter(6.486e-05), .dbv(0), .m(1), .par1(1))
(* integer passed_mfactor = "m"; *)
 D4_12 (GNDOI1, GNDOI2);
dp3 #(.area(5.91506e-11), .perimeter(6.486e-05), .dbv(0), .m(1), .par1(1))
(* integer passed_mfactor = "m"; *)
 D4_13 (GNDOI1, GNDOI2);
dp3 #(.area(5.91506e-11), .perimeter(6.486e-05), .dbv(0), .m(1), .par1(1))
(* integer passed_mfactor = "m"; *)
 D4_14 (GNDOI1, GNDOI2);
dp3 #(.area(5.91506e-11), .perimeter(6.486e-05), .dbv(0), .m(1), .par1(1))
(* integer passed_mfactor = "m"; *)
 D1_1 (GNDOI2, GNDOI1);
dp3 #(.area(5.91506e-11), .perimeter(6.486e-05), .dbv(0), .m(1), .par1(1))
(* integer passed_mfactor = "m"; *)
 D1_2 (GNDOI2, GNDOI1);
dp3 #(.area(5.91506e-11), .perimeter(6.486e-05), .dbv(0), .m(1), .par1(1))
(* integer passed_mfactor = "m"; *)
 D1_3 (GNDOI2, GNDOI1);
dp3 #(.area(5.91506e-11), .perimeter(6.486e-05), .dbv(0), .m(1), .par1(1))
(* integer passed_mfactor = "m"; *)
 D1_4 (GNDOI2, GNDOI1);
dp3 #(.area(5.91506e-11), .perimeter(6.486e-05), .dbv(0), .m(1), .par1(1))
(* integer passed_mfactor = "m"; *)
 D1_5 (GNDOI2, GNDOI1);
dp3 #(.area(5.91506e-11), .perimeter(6.486e-05), .dbv(0), .m(1), .par1(1))
(* integer passed_mfactor = "m"; *)
 D1_6 (GNDOI2, GNDOI1);
dp3 #(.area(5.91506e-11), .perimeter(6.486e-05), .dbv(0), .m(1), .par1(1))
(* integer passed_mfactor = "m"; *)
 D1_7 (GNDOI2, GNDOI1);
dp3 #(.area(5.91506e-11), .perimeter(6.486e-05), .dbv(0), .m(1), .par1(1))
(* integer passed_mfactor = "m"; *)
 D1_8 (GNDOI2, GNDOI1);
dp3 #(.area(5.91506e-11), .perimeter(6.486e-05), .dbv(0), .m(1), .par1(1))
(* integer passed_mfactor = "m"; *)
 D1_9 (GNDOI2, GNDOI1);
dp3 #(.area(5.91506e-11), .perimeter(6.486e-05), .dbv(0), .m(1), .par1(1))
(* integer passed_mfactor = "m"; *)
 D1_10 (GNDOI2, GNDOI1);
dp3 #(.area(5.91506e-11), .perimeter(6.486e-05), .dbv(0), .m(1), .par1(1))
(* integer passed_mfactor = "m"; *)
 D1_11 (GNDOI2, GNDOI1);
dp3 #(.area(5.91506e-11), .perimeter(6.486e-05), .dbv(0), .m(1), .par1(1))
(* integer passed_mfactor = "m"; *)
 D1_12 (GNDOI2, GNDOI1);
dp3 #(.area(5.91506e-11), .perimeter(6.486e-05), .dbv(0), .m(1), .par1(1))
(* integer passed_mfactor = "m"; *)
 D1_13 (GNDOI2, GNDOI1);
dp3 #(.area(5.91506e-11), .perimeter(6.486e-05), .dbv(0), .m(1), .par1(1))
(* integer passed_mfactor = "m"; *)
 D1_14 (GNDOI2, GNDOI1);
dp3 #(.area(5.91506e-11), .perimeter(6.486e-05), .dbv(0), .m(1), .par1(1))
(* integer passed_mfactor = "m"; *)
 D1_15 (GNDOI2, GNDOI1);

endmodule
// Library - IO_CELLS_JIC3V, Cell - jio_tp4_pc, View - cmos_sch
// LAST TIME SAVED: Nov 16 02:00:07 2021
// NETLIST TIME: Feb  9 05:16:35 2024

`worklib IO_CELLS_JIC3V
`view cmos_sch

`timescale 1ns / 1ps
(* cds_ams_schematic *)

module jio_tp4_pc (NG1, NG2, PG1, PG2, GNDO, NG, NW, PG, PW, VDDO);
output  NG1, NG2, PG1, PG2;
input  GNDO, NG, NW, PG, PW, VDDO;
ne3i #(.w(6.1e-06), .l(4e-07), .as(9.6e-13), .ad(9.6e-13), .ps(4.96e-06), .pd(4.96e-06), .nrs(0.135), .nrd(0.135), .m((1)*(1)), .par1((1)*(1)))
(* integer passed_mfactor = "m"; *)
 M11 (PG1, PG, GNDO, PW);
ne3i #(.w(3.7e-06), .l(4e-07), .as(9.6e-13), .ad(9.6e-13), .ps(4.96e-06), .pd(4.96e-06), .nrs(0.135), .nrd(0.135), .m((1)*(1)), .par1((1)*(1)))
(* integer passed_mfactor = "m"; *)
 M13 (PG2, PG, net26, PW);
ne3i #(.w(5.5e-06), .l(4e-07), .as(9.6e-13), .ad(9.6e-13), .ps(4.96e-06), .pd(4.96e-06), .nrs(0.135), .nrd(0.135), .m((1)*(2)), .par1((1)*(2)))
(* integer passed_mfactor = "m"; *)
 M21 (NG1, NG, GNDO, PW);
ne3i #(.w(3.7e-06), .l(4e-07), .as(9.6e-13), .ad(9.6e-13), .ps(4.96e-06), .pd(4.96e-06), .nrs(0.135), .nrd(0.135), .m((1)*(1)), .par1((1)*(1)))
(* integer passed_mfactor = "m"; *)
 M14 (net26, PG, GNDO, PW);
ne3i #(.w(8e-06), .l(4e-07), .as(9.6e-13), .ad(9.6e-13), .ps(4.96e-06), .pd(4.96e-06), .nrs(0.135), .nrd(0.135), .m((1)*(2)), .par1((1)*(2)))
(* integer passed_mfactor = "m"; *)
 M24 (NG2, NG, GNDO, PW);
pe3i #(.w(1e-05), .l(3.5e-07), .as(4.8e-12), .ad(2.7e-12), .ps(2.096e-05), .pd(1.054e-05), .nrs(0.027), .nrd(0.027), .m((1)*(2)), .par1((1)*(2)))
(* integer passed_mfactor = "m"; *)
 M10 (PG1, PG, VDDO, NW);
pe3i #(.w(4.9e-06), .l(3.5e-07), .as(9.6e-13), .ad(9.6e-13), .ps(4.96e-06), .pd(4.96e-06), .nrs(0.135), .nrd(0.135), .m((1)*(1)), .par1((1)*(1)))
(* integer passed_mfactor = "m"; *)
 M20 (NG1, NG, VDDO, NW);
pe3i #(.w(6.7e-06), .l(4e-07), .as(9.6e-13), .ad(9.6e-13), .ps(4.96e-06), .pd(4.96e-06), .nrs(0.135), .nrd(0.135), .m((1)*(1)), .par1((1)*(1)))
(* integer passed_mfactor = "m"; *)
 M23 (NG2, NG, net25, NW);
pe3i #(.w(6.7e-06), .l(4e-07), .as(9.6e-13), .ad(9.6e-13), .ps(4.96e-06), .pd(4.96e-06), .nrs(0.135), .nrd(0.135), .m((1)*(1)), .par1((1)*(1)))
(* integer passed_mfactor = "m"; *)
 M22 (net25, NG, VDDO, NW);
pe3i #(.w(1e-05), .l(3.5e-07), .as(4.8e-12), .ad(2.7e-12), .ps(2.096e-05), .pd(1.054e-05), .nrs(0.027), .nrd(0.027), .m((1)*(2)), .par1((1)*(2)))
(* integer passed_mfactor = "m"; *)
 M12 (PG2, PG, VDDO, NW);

endmodule
// Library - IO_CELLS_JIC3V, Cell - jio_tsctrl_pc, View - cmos_sch
// LAST TIME SAVED: Nov 16 02:00:00 2021
// NETLIST TIME: Feb  9 05:16:35 2024

`worklib IO_CELLS_JIC3V
`view cmos_sch

`timescale 1ns / 1ps
(* cds_ams_schematic *)

module jio_tsctrl_pc (NG, PG, A, EN, GND, GNDO, VDD, VDDO);
output  NG, PG;
input  A, EN, GND, GNDO, VDD, VDDO;
pe3i #(.w(5.2e-06), .l(3.5e-07), .as(2.496e-12), .ad(1.404e-12), .ps(1.136e-05), .pd(5.74e-06), .nrs(0.0519231), .nrd(0.0519231), .m((1)*(2)), .par1((1)*(2)))
(* integer passed_mfactor = "m"; *)
 M127 (NG, NGB, VDDO, VDDO);
pe3i #(.w(5.2e-06), .l(3.5e-07), .as(2.496e-12), .ad(1.404e-12), .ps(1.136e-05), .pd(5.74e-06), .nrs(0.0519231), .nrd(0.0519231), .m((1)*(2)), .par1((1)*(2)))
(* integer passed_mfactor = "m"; *)
 M117 (PG, PGB, VDDO, VDDO);
pe3i #(.w(2.16e-06), .l(3.5e-07), .as(1.0368e-12), .ad(1.0368e-12), .ps(5.28e-06), .pd(5.28e-06), .nrs(0.125), .nrd(0.125), .m((1)*(1)), .par1((1)*(1)))
(* integer passed_mfactor = "m"; *)
 M01 (ENB, EN, VDD, VDD);
pe3i #(.w(2.16e-06), .l(3.5e-07), .as(1.0368e-12), .ad(1.0368e-12), .ps(5.28e-06), .pd(5.28e-06), .nrs(0.125), .nrd(0.125), .m((1)*(1)), .par1((1)*(1)))
(* integer passed_mfactor = "m"; *)
 M22 (NGB, EN, net49, VDD);
pe3i #(.w(2.16e-06), .l(3.5e-07), .as(1.0368e-12), .ad(1.0368e-12), .ps(5.28e-06), .pd(5.28e-06), .nrs(0.125), .nrd(0.125), .m((1)*(1)), .par1((1)*(1)))
(* integer passed_mfactor = "m"; *)
 M12 (PGB, ENB, VDD, VDD);
pe3i #(.w(2.16e-06), .l(3.5e-07), .as(1.0368e-12), .ad(1.0368e-12), .ps(5.28e-06), .pd(5.28e-06), .nrs(0.125), .nrd(0.125), .m((1)*(1)), .par1((1)*(1)))
(* integer passed_mfactor = "m"; *)
 M21 (net49, A, VDD, VDD);
pe3i #(.w(2.16e-06), .l(3.5e-07), .as(1.0368e-12), .ad(1.0368e-12), .ps(5.28e-06), .pd(5.28e-06), .nrs(0.125), .nrd(0.125), .m((1)*(1)), .par1((1)*(1)))
(* integer passed_mfactor = "m"; *)
 M11 (PGB, A, VDD, VDD);
ne3i #(.w(5.2e-06), .l(4e-07), .as(2.496e-12), .ad(2.496e-12), .ps(1.136e-05), .pd(1.136e-05), .nrs(0.0519231), .nrd(0.0519231), .m((1)*(1)), .par1((1)*(1)))
(* integer passed_mfactor = "m"; *)
 M128 (NG, NGB, GNDO, GNDO);
ne3i #(.w(5.2e-06), .l(4e-07), .as(2.496e-12), .ad(2.496e-12), .ps(1.136e-05), .pd(1.136e-05), .nrs(0.0519231), .nrd(0.0519231), .m((1)*(1)), .par1((1)*(1)))
(* integer passed_mfactor = "m"; *)
 M118 (PG, PGB, GNDO, GNDO);
ne3i #(.w(1.1e-06), .l(4e-07), .as(5.28e-13), .ad(5.28e-13), .ps(3.16e-06), .pd(3.16e-06), .nrs(0.245455), .nrd(0.245455), .m((1)*(1)), .par1((1)*(1)))
(* integer passed_mfactor = "m"; *)
 M02 (ENB, EN, GND, GND);
ne3i #(.w(1.1e-06), .l(4e-07), .as(5.28e-13), .ad(2.97e-13), .ps(3.16e-06), .pd(1.64e-06), .nrs(0.245455), .nrd(0.245455), .m((1)*(2)), .par1((1)*(2)))
(* integer passed_mfactor = "m"; *)
 M24 (NGB, A, GND, GND);
ne3i #(.w(1.1e-06), .l(4e-07), .as(5.28e-13), .ad(2.97e-13), .ps(3.16e-06), .pd(1.64e-06), .nrs(0.245455), .nrd(0.245455), .m((1)*(2)), .par1((1)*(2)))
(* integer passed_mfactor = "m"; *)
 M15 (net50, A, GND, GND);
ne3i #(.w(1.1e-06), .l(4e-07), .as(5.28e-13), .ad(2.97e-13), .ps(3.16e-06), .pd(1.64e-06), .nrs(0.245455), .nrd(0.245455), .m((1)*(2)), .par1((1)*(2)))
(* integer passed_mfactor = "m"; *)
 M25 (NGB, EN, GND, GND);
ne3i #(.w(1.1e-06), .l(4e-07), .as(5.28e-13), .ad(2.97e-13), .ps(3.16e-06), .pd(1.64e-06), .nrs(0.245455), .nrd(0.245455), .m((1)*(2)), .par1((1)*(2)))
(* integer passed_mfactor = "m"; *)
 M14 (PGB, ENB, net50, GND);

endmodule
// Library - IO_CELLS_JIC3V, Cell - VDDORPADPC, View - cmos_sch
// LAST TIME SAVED: Nov 16 11:04:45 2021
// NETLIST TIME: Feb  9 05:16:35 2024

`worklib IO_CELLS_JIC3V
`view cmos_sch

`timescale 1ns / 1ps
(* cds_ams_schematic *)

module VDDORPADPC (GNDI, GNDOI, GNDRI, PSUB, VDD3I, VDDORI);
input  GNDI, GNDOI, GNDRI, PSUB, VDD3I, VDDORI;
wire ng;
jio_ne3i_pc IN_1 (.D( VDDORI ), .B( GNDOI ), .G( ng ), .S( GNDOI ));
jio_ne3i_pc IN_2 (.D( VDDORI ), .B( GNDOI ), .G( ng ), .S( GNDOI ));
jio_ne3i_pc IN_3 (.D( VDDORI ), .B( GNDOI ), .G( ng ), .S( GNDOI ));
jio_ne3i_pc IN_4 (.D( VDDORI ), .B( GNDOI ), .G( ng ), .S( GNDOI ));
jio_ne3i_pc IN_5 (.D( VDDORI ), .B( GNDOI ), .G( ng ), .S( GNDOI ));
jio_ne3i_pc IN_6 (.D( VDDORI ), .B( GNDOI ), .G( ng ), .S( GNDOI ));
jio_ne3i_pc IN_7 (.D( VDDORI ), .B( GNDOI ), .G( ng ), .S( GNDOI ));
jio_ne3i_pc IN_8 (.D( VDDORI ), .B( GNDOI ), .G( ng ), .S( GNDOI ));
jio_ne3i_pc IN_9 (.D( VDDORI ), .B( GNDOI ), .G( ng ), .S( GNDOI ));
jio_ne3i_pc IN_10 (.D( VDDORI ), .B( GNDOI ), .G( ng ), .S( GNDOI ));
jio_ne3i_pc IN_11 (.D( VDDORI ), .B( GNDOI ), .G( ng ), .S( GNDOI ));
jio_ne3i_pc IN_12 (.D( VDDORI ), .B( GNDOI ), .G( ng ), .S( GNDOI ));
jio_ne3i_pc IN_13 (.D( VDDORI ), .B( GNDOI ), .G( ng ), .S( GNDOI ));
jio_ne3i_pc IN_14 (.D( VDDORI ), .B( GNDOI ), .G( ng ), .S( GNDOI ));
jio_ne3i_pc IN_15 (.D( VDDORI ), .B( GNDOI ), .G( ng ), .S( GNDOI ));
jio_ne3i_pc IN_16 (.D( VDDORI ), .B( GNDOI ), .G( ng ), .S( GNDOI ));
jio_ne3i_pc IN_17 (.D( VDDORI ), .B( GNDOI ), .G( ng ), .S( GNDOI ));
jio_ne3i_pc IN_18 (.D( VDDORI ), .B( GNDOI ), .G( ng ), .S( GNDOI ));
jio_ne3i_pc IN_19 (.D( VDDORI ), .B( GNDOI ), .G( ng ), .S( GNDOI ));
jio_ne3i_pc IN_20 (.D( VDDORI ), .B( GNDOI ), .G( ng ), .S( GNDOI ));
jio_ne3i_pc IN_21 (.D( VDDORI ), .B( GNDOI ), .G( ng ), .S( GNDOI ));
jio_ne3i_pc IN_22 (.D( VDDORI ), .B( GNDOI ), .G( ng ), .S( GNDOI ));
jio_ne3i_pc IN_23 (.D( VDDORI ), .B( GNDOI ), .G( ng ), .S( GNDOI ));
jio_ne3i_pc IN_24 (.D( VDDORI ), .B( GNDOI ), .G( ng ), .S( GNDOI ));
jio_andio_pc I157 (.DNW( VDDORI ), .PWI( GNDOI ), .PSUB( PSUB ));
rdp3 #(.l(3.3e-06), .w(4.4e-07), .m(1), .par1(1))
(* integer passed_mfactor = "m"; *)
 R11 (ng, GNDOI, VDDORI);

endmodule
// Library - IO_CELLS_JIC3V, Cell - jio_ts4_pc, View - cmos_sch
// LAST TIME SAVED: Nov 16 02:00:01 2021
// NETLIST TIME: Feb  9 05:16:35 2024

`worklib IO_CELLS_JIC3V
`view cmos_sch

`timescale 1ns / 1ps
(* cds_ams_schematic *)

module jio_ts4_pc (PAD, A, EN, GND, GNDO, PSUB, VDD, VDDO, VDN);
output  PAD;
input  A, EN, GND, GNDO, PSUB, VDD, VDDO, VDN;
wire pg1;
wire pg2;
wire rh;
wire ng3;
wire ng2;
wire ng1;
wire pg;
wire ng;
jio_pe3i_pc IP1_1 (.D( PAD ), .B( VDDO ), .G( pg1 ), .S( VDDO ));
jio_pe3i_pc IP1_2 (.D( PAD ), .B( VDDO ), .G( pg1 ), .S( VDDO ));
jio_pe3i_pc IP1_3 (.D( PAD ), .B( VDDO ), .G( pg1 ), .S( VDDO ));
jio_pe3i_pc IP2_1 (.D( PAD ), .B( VDDO ), .G( pg2 ), .S( VDDO ));
jio_pe3i_pc IP2_2 (.D( PAD ), .B( VDDO ), .G( pg2 ), .S( VDDO ));
jio_pe3i_pc IP2_3 (.D( PAD ), .B( VDDO ), .G( pg2 ), .S( VDDO ));
jio_pe3i_pc IP3_1 (.S( VDDO ), .G( rh ), .B( VDDO ), .D( PAD ));
jio_pe3i_pc IP3_2 (.S( VDDO ), .G( rh ), .B( VDDO ), .D( PAD ));
jio_pe3i_pc IP3_3 (.S( VDDO ), .G( rh ), .B( VDDO ), .D( PAD ));
jio_pe3i_pc IP3_4 (.S( VDDO ), .G( rh ), .B( VDDO ), .D( PAD ));
jio_pe3i_pc IP3_5 (.S( VDDO ), .G( rh ), .B( VDDO ), .D( PAD ));
jio_pe3i_pc IP3_6 (.S( VDDO ), .G( rh ), .B( VDDO ), .D( PAD ));
jio_pe3i_pc IP3_7 (.S( VDDO ), .G( rh ), .B( VDDO ), .D( PAD ));
jio_pe3i_pc IP3_8 (.S( VDDO ), .G( rh ), .B( VDDO ), .D( PAD ));
jio_pe3i_pc IP3_9 (.S( VDDO ), .G( rh ), .B( VDDO ), .D( PAD ));
jio_pe3i_pc IP3_10 (.S( VDDO ), .G( rh ), .B( VDDO ), .D( PAD ));
jio_pe3i_pc IP3_11 (.S( VDDO ), .G( rh ), .B( VDDO ), .D( PAD ));
jio_pe3i_pc IP3_12 (.S( VDDO ), .G( rh ), .B( VDDO ), .D( PAD ));
jio_pe3i_pc IP3_13 (.S( VDDO ), .G( rh ), .B( VDDO ), .D( PAD ));
jio_pe3i_pc IP3_14 (.S( VDDO ), .G( rh ), .B( VDDO ), .D( PAD ));
jio_pe3i_pc IP3_15 (.S( VDDO ), .G( rh ), .B( VDDO ), .D( PAD ));
jio_pe3i_pc IP3_16 (.S( VDDO ), .G( rh ), .B( VDDO ), .D( PAD ));
jio_pe3i_pc IP3_17 (.S( VDDO ), .G( rh ), .B( VDDO ), .D( PAD ));
jio_pe3i_pc IP3_18 (.S( VDDO ), .G( rh ), .B( VDDO ), .D( PAD ));
jio_resp_pc I5 (.RH( rh ), .VDDO( VDDO ), .GNDO( GNDO ));
jio_opdio_pc I3 (.VDN( VDN ), .PSUB( PSUB ), .NW( VDDO ), .DNLW( VDD ), .DNW( VDDO ), .PWI( GNDO ), .LPWI( GND ));
jio_ne3i_pc IN3_1 (.D( PAD ), .B( GNDO ), .G( ng3 ), .S( GNDO ));
jio_ne3i_pc IN3_2 (.D( PAD ), .B( GNDO ), .G( ng3 ), .S( GNDO ));
jio_ne3i_pc IN3_3 (.D( PAD ), .B( GNDO ), .G( ng3 ), .S( GNDO ));
jio_ne3i_pc IN3_4 (.D( PAD ), .B( GNDO ), .G( ng3 ), .S( GNDO ));
jio_ne3i_pc IN3_5 (.D( PAD ), .B( GNDO ), .G( ng3 ), .S( GNDO ));
jio_ne3i_pc IN3_6 (.D( PAD ), .B( GNDO ), .G( ng3 ), .S( GNDO ));
jio_ne3i_pc IN3_7 (.D( PAD ), .B( GNDO ), .G( ng3 ), .S( GNDO ));
jio_ne3i_pc IN3_8 (.D( PAD ), .B( GNDO ), .G( ng3 ), .S( GNDO ));
jio_ne3i_pc IN3_9 (.D( PAD ), .B( GNDO ), .G( ng3 ), .S( GNDO ));
jio_ne3i_pc IN3_10 (.D( PAD ), .B( GNDO ), .G( ng3 ), .S( GNDO ));
jio_ne3i_pc IN3_11 (.D( PAD ), .B( GNDO ), .G( ng3 ), .S( GNDO ));
jio_ne3i_pc IN3_12 (.D( PAD ), .B( GNDO ), .G( ng3 ), .S( GNDO ));
jio_ne3i_pc IN3_13 (.D( PAD ), .B( GNDO ), .G( ng3 ), .S( GNDO ));
jio_ne3i_pc IN3_14 (.D( PAD ), .B( GNDO ), .G( ng3 ), .S( GNDO ));
jio_ne3i_pc IN3_15 (.D( PAD ), .B( GNDO ), .G( ng3 ), .S( GNDO ));
jio_ne3i_pc IN3_16 (.D( PAD ), .B( GNDO ), .G( ng3 ), .S( GNDO ));
jio_ne3i_pc IN3_17 (.D( PAD ), .B( GNDO ), .G( ng3 ), .S( GNDO ));
jio_ne3i_pc IN3_18 (.D( PAD ), .B( GNDO ), .G( ng3 ), .S( GNDO ));
jio_ne3i_pc IN3_19 (.D( PAD ), .B( GNDO ), .G( ng3 ), .S( GNDO ));
jio_ne3i_pc IN3_20 (.D( PAD ), .B( GNDO ), .G( ng3 ), .S( GNDO ));
jio_ne3i_pc IN3_21 (.D( PAD ), .B( GNDO ), .G( ng3 ), .S( GNDO ));
jio_ne3i_pc IN2_1 (.S( GNDO ), .G( ng2 ), .B( GNDO ), .D( PAD ));
jio_ne3i_pc IN2_2 (.S( GNDO ), .G( ng2 ), .B( GNDO ), .D( PAD ));
jio_ne3i_pc IN1 (.S( GNDO ), .G( ng1 ), .B( GNDO ), .D( PAD ));
jio_tp4_pc I2 (.NW( VDDO ), .NG1( ng1 ), .NG( ng ), .VDDO( VDDO ), .PG( pg ), .PG1( pg1 ), .PG2( pg2 ), .PW( GNDO ), .GNDO( GNDO ), .NG2( ng2 ));
jio_tsctrl_pc I1 (.VDDO( VDDO ), .PG( pg ), .NG( ng ), .VDD( VDD ), .GNDO( GNDO ), .EN( EN ), .GND( GND ), .A( A ));
ne3i #(.w(1.2e-06), .l(4e-07), .as(9.6e-13), .ad(9.6e-13), .ps(4.96e-06), .pd(4.96e-06), .nrs(0.135), .nrd(0.135), .m((1)*(1)), .par1((1)*(1)))
(* integer passed_mfactor = "m"; *)
 M0 (ng3, rh, GNDO, GNDO);

endmodule
// Library - IO_CELLS_JIC3V, Cell - BT4PC, View - cmos_sch
// LAST TIME SAVED: Nov 16 02:00:29 2021
// NETLIST TIME: Feb  9 05:16:35 2024

`worklib IO_CELLS_JIC3V
`view cmos_sch

`timescale 1ns / 1ps
(* cds_ams_schematic *)

module BT4PC (PAD, A, EN, GNDI, GNDOI, GNDRI, PSUB, VDD3I, VDDOI, VDDRI);
output  PAD;
input  A, EN, GNDI, GNDOI, GNDRI, PSUB, VDD3I, VDDOI, VDDRI;
jio_ts4_pc I0 (.A( A ), .PAD( PAD ), .EN( EN ), .VDDO( VDDOI ), .VDD( VDD3I ), .GNDO( GNDOI ), .PSUB( PSUB ), .VDN( VDDOI ), .GND( GNDI ));
jio_ipdio_pc I5 (.PSUB( PSUB ), .DNWR( VDDRI ), .PWIR( GNDRI ));

endmodule
// Library - IO_CELLS_JIC3V, Cell - jio_anrdio_pc, View - cmos_sch
// LAST TIME SAVED: Nov 16 02:00:21 2021
// NETLIST TIME: Feb  9 05:16:35 2024

`worklib IO_CELLS_JIC3V
`view cmos_sch

`timescale 1ns / 1ps
(* cds_ams_schematic *)

module jio_anrdio_pc (DNLW, DNW, LPWI, NW, PSUB, PWI, VDN);
input  DNLW, DNW, LPWI, NW, PSUB, PWI, VDN;
ddnwmv #(.area(9.789e-10), .perimeter(0.00016012), .dbv(0), .m(1), .par1(1), .xf_subext(0))
(* integer passed_mfactor = "m"; *)
 D5 (PSUB, DNLW);
ddnwmv #(.area(4.69976e-09), .perimeter(0.00027464), .dbv(0), .m(1), .par1(1), .xf_subext(0))
(* integer passed_mfactor = "m"; *)
 D0 (PSUB, VDN);
ddnwmv #(.area(9.8345e-10), .perimeter(0.00016026), .dbv(0), .m(1), .par1(1), .xf_subext(0))
(* integer passed_mfactor = "m"; *)
 D6 (PSUB, DNW);
dipdnwmv #(.area(4.16648e-09), .perimeter(0.00025864), .dbv(0), .m(1), .par1(1))
(* integer passed_mfactor = "m"; *)
 D1 (PWI, VDN);
dipdnwmv #(.area(2.1664e-10), .perimeter(5.908e-05), .dbv(0), .m(1), .par1(1))
(* integer passed_mfactor = "m"; *)
 D2 (PWI, NW);
dipdnwmv #(.area(1.2696e-10), .perimeter(4.787e-05), .dbv(0), .m(1), .par1(1))
(* integer passed_mfactor = "m"; *)
 D4 (PWI, NW);

endmodule
// Library - IO_CELLS_JIC3V, Cell - APR04DPC, View - cmos_sch
// LAST TIME SAVED: Nov 16 10:56:44 2021
// NETLIST TIME: Feb  9 05:16:35 2024

`worklib IO_CELLS_JIC3V
`view cmos_sch

`timescale 1ns / 1ps
(* cds_ams_schematic *)

module APR04DPC (Y, GNDI, GNDOI, GNDRI, PAD, PSUB, VDD3I, VDDOI, VDDRI);
output  Y;
input  GNDI, GNDOI, GNDRI, PAD, PSUB, VDD3I, VDDOI, VDDRI;
wire ng;
wire rh;
jio_ne3is_pc INS_1 (.D( Y ), .B( GNDOI ), .G( GNDOI ), .S( GNDOI ));
jio_ne3is_pc INS_2 (.D( Y ), .B( GNDOI ), .G( GNDOI ), .S( GNDOI ));
jio_ne3i_pc IN_1 (.D( PAD ), .B( GNDOI ), .G( ng ), .S( GNDOI ));
jio_ne3i_pc IN_2 (.D( PAD ), .B( GNDOI ), .G( ng ), .S( GNDOI ));
jio_ne3i_pc IN_3 (.D( PAD ), .B( GNDOI ), .G( ng ), .S( GNDOI ));
jio_ne3i_pc IN_4 (.D( PAD ), .B( GNDOI ), .G( ng ), .S( GNDOI ));
jio_ne3i_pc IN_5 (.D( PAD ), .B( GNDOI ), .G( ng ), .S( GNDOI ));
jio_ne3i_pc IN_6 (.D( PAD ), .B( GNDOI ), .G( ng ), .S( GNDOI ));
jio_ne3i_pc IN_7 (.D( PAD ), .B( GNDOI ), .G( ng ), .S( GNDOI ));
jio_ne3i_pc IN_8 (.D( PAD ), .B( GNDOI ), .G( ng ), .S( GNDOI ));
jio_ne3i_pc IN_9 (.D( PAD ), .B( GNDOI ), .G( ng ), .S( GNDOI ));
jio_ne3i_pc IN_10 (.D( PAD ), .B( GNDOI ), .G( ng ), .S( GNDOI ));
jio_ne3i_pc IN_11 (.D( PAD ), .B( GNDOI ), .G( ng ), .S( GNDOI ));
jio_ne3i_pc IN_12 (.D( PAD ), .B( GNDOI ), .G( ng ), .S( GNDOI ));
jio_ne3i_pc IN_13 (.D( PAD ), .B( GNDOI ), .G( ng ), .S( GNDOI ));
jio_ne3i_pc IN_14 (.D( PAD ), .B( GNDOI ), .G( ng ), .S( GNDOI ));
jio_ne3i_pc IN_15 (.D( PAD ), .B( GNDOI ), .G( ng ), .S( GNDOI ));
jio_ne3i_pc IN_16 (.D( PAD ), .B( GNDOI ), .G( ng ), .S( GNDOI ));
jio_ne3i_pc IN_17 (.D( PAD ), .B( GNDOI ), .G( ng ), .S( GNDOI ));
jio_ne3i_pc IN_18 (.D( PAD ), .B( GNDOI ), .G( ng ), .S( GNDOI ));
jio_ne3i_pc IN_19 (.D( PAD ), .B( GNDOI ), .G( ng ), .S( GNDOI ));
jio_ne3i_pc IN_20 (.D( PAD ), .B( GNDOI ), .G( ng ), .S( GNDOI ));
jio_ne3i_pc IN_21 (.D( PAD ), .B( GNDOI ), .G( ng ), .S( GNDOI ));
jio_ne3i_pc IN_22 (.D( PAD ), .B( GNDOI ), .G( ng ), .S( GNDOI ));
jio_ne3i_pc IN_23 (.D( PAD ), .B( GNDOI ), .G( ng ), .S( GNDOI ));
jio_ne3i_pc IN_24 (.D( PAD ), .B( GNDOI ), .G( ng ), .S( GNDOI ));
jio_resp_pc I3 (.RH( rh ), .VDDO( VDDOI ), .GNDO( GNDOI ));
jio_pe3i_pc IP_1 (.S( VDDOI ), .G( rh ), .B( VDDOI ), .D( PAD ));
jio_pe3i_pc IP_2 (.S( VDDOI ), .G( rh ), .B( VDDOI ), .D( PAD ));
jio_pe3i_pc IP_3 (.S( VDDOI ), .G( rh ), .B( VDDOI ), .D( PAD ));
jio_pe3i_pc IP_4 (.S( VDDOI ), .G( rh ), .B( VDDOI ), .D( PAD ));
jio_pe3i_pc IP_5 (.S( VDDOI ), .G( rh ), .B( VDDOI ), .D( PAD ));
jio_pe3i_pc IP_6 (.S( VDDOI ), .G( rh ), .B( VDDOI ), .D( PAD ));
jio_pe3i_pc IP_7 (.S( VDDOI ), .G( rh ), .B( VDDOI ), .D( PAD ));
jio_pe3i_pc IP_8 (.S( VDDOI ), .G( rh ), .B( VDDOI ), .D( PAD ));
jio_pe3i_pc IP_9 (.S( VDDOI ), .G( rh ), .B( VDDOI ), .D( PAD ));
jio_pe3i_pc IP_10 (.S( VDDOI ), .G( rh ), .B( VDDOI ), .D( PAD ));
jio_pe3i_pc IP_11 (.S( VDDOI ), .G( rh ), .B( VDDOI ), .D( PAD ));
jio_pe3i_pc IP_12 (.S( VDDOI ), .G( rh ), .B( VDDOI ), .D( PAD ));
jio_pe3i_pc IP_13 (.S( VDDOI ), .G( rh ), .B( VDDOI ), .D( PAD ));
jio_pe3i_pc IP_14 (.S( VDDOI ), .G( rh ), .B( VDDOI ), .D( PAD ));
jio_pe3i_pc IP_15 (.S( VDDOI ), .G( rh ), .B( VDDOI ), .D( PAD ));
jio_pe3i_pc IP_16 (.S( VDDOI ), .G( rh ), .B( VDDOI ), .D( PAD ));
jio_pe3i_pc IP_17 (.S( VDDOI ), .G( rh ), .B( VDDOI ), .D( PAD ));
jio_pe3i_pc IP_18 (.S( VDDOI ), .G( rh ), .B( VDDOI ), .D( PAD ));
jio_pe3i_pc IP_19 (.S( VDDOI ), .G( rh ), .B( VDDOI ), .D( PAD ));
jio_pe3i_pc IP_20 (.S( VDDOI ), .G( rh ), .B( VDDOI ), .D( PAD ));
jio_pe3i_pc IP_21 (.S( VDDOI ), .G( rh ), .B( VDDOI ), .D( PAD ));
jio_pe3i_pc IP_22 (.S( VDDOI ), .G( rh ), .B( VDDOI ), .D( PAD ));
jio_pe3i_pc IP_23 (.S( VDDOI ), .G( rh ), .B( VDDOI ), .D( PAD ));
jio_pe3i_pc IP_24 (.S( VDDOI ), .G( rh ), .B( VDDOI ), .D( PAD ));
jio_anrdio_pc I157 (.NW( VDDOI ), .PSUB( PSUB ), .LPWI( GNDI ), .VDN( VDDOI ), .PWI( GNDOI ), .DNW( VDDOI ), .DNLW( VDD3I ));
ne3i #(.w(1.2e-06), .l(4e-07), .as(5.76e-13), .ad(5.76e-13), .ps(3.36e-06), .pd(3.36e-06), .nrs(0.225), .nrd(0.225), .m((1)*(1)), .par1((1)*(1)))
(* integer passed_mfactor = "m"; *)
 M2 (ng, rh, GNDOI, GNDOI);
pe3i #(.w(1.2e-05), .l(3.5e-07), .as(5.76e-12), .ad(3.24e-12), .ps(2.496e-05), .pd(1.254e-05), .nrs(0.0225), .nrd(0.0225), .m((1)*(2)), .par1((1)*(2)))
(* integer passed_mfactor = "m"; *)
 M3 (Y, VDDOI, VDDOI, VDDOI);
rpp1 #(.l(2.2e-06), .w(2e-06), .m(1), .par1(1))
(* integer passed_mfactor = "m"; *)
 R1 (PAD, Y);

endmodule
// Library - IO_CELLS_JIC3V, Cell - APR00DPC, View - cmos_sch
// LAST TIME SAVED: Nov 16 10:55:26 2021
// NETLIST TIME: Feb  9 05:16:35 2024

`worklib IO_CELLS_JIC3V
`view cmos_sch

`timescale 1ns / 1ps
(* cds_ams_schematic *)

module APR00DPC (PAD, GNDI, GNDOI, GNDRI, PSUB, VDD3I, VDDOI, VDDRI);
input  GNDI, GNDOI, GNDRI, PSUB, VDD3I, VDDOI, VDDRI;
inout  PAD;
wire ng;
wire pg;
jio_ne3i_pc IN_1 (.D( PAD ), .B( GNDOI ), .G( ng ), .S( GNDOI ));
jio_ne3i_pc IN_2 (.D( PAD ), .B( GNDOI ), .G( ng ), .S( GNDOI ));
jio_ne3i_pc IN_3 (.D( PAD ), .B( GNDOI ), .G( ng ), .S( GNDOI ));
jio_ne3i_pc IN_4 (.D( PAD ), .B( GNDOI ), .G( ng ), .S( GNDOI ));
jio_ne3i_pc IN_5 (.D( PAD ), .B( GNDOI ), .G( ng ), .S( GNDOI ));
jio_ne3i_pc IN_6 (.D( PAD ), .B( GNDOI ), .G( ng ), .S( GNDOI ));
jio_ne3i_pc IN_7 (.D( PAD ), .B( GNDOI ), .G( ng ), .S( GNDOI ));
jio_ne3i_pc IN_8 (.D( PAD ), .B( GNDOI ), .G( ng ), .S( GNDOI ));
jio_ne3i_pc IN_9 (.D( PAD ), .B( GNDOI ), .G( ng ), .S( GNDOI ));
jio_ne3i_pc IN_10 (.D( PAD ), .B( GNDOI ), .G( ng ), .S( GNDOI ));
jio_ne3i_pc IN_11 (.D( PAD ), .B( GNDOI ), .G( ng ), .S( GNDOI ));
jio_ne3i_pc IN_12 (.D( PAD ), .B( GNDOI ), .G( ng ), .S( GNDOI ));
jio_ne3i_pc IN_13 (.D( PAD ), .B( GNDOI ), .G( ng ), .S( GNDOI ));
jio_ne3i_pc IN_14 (.D( PAD ), .B( GNDOI ), .G( ng ), .S( GNDOI ));
jio_ne3i_pc IN_15 (.D( PAD ), .B( GNDOI ), .G( ng ), .S( GNDOI ));
jio_ne3i_pc IN_16 (.D( PAD ), .B( GNDOI ), .G( ng ), .S( GNDOI ));
jio_ne3i_pc IN_17 (.D( PAD ), .B( GNDOI ), .G( ng ), .S( GNDOI ));
jio_ne3i_pc IN_18 (.D( PAD ), .B( GNDOI ), .G( ng ), .S( GNDOI ));
jio_ne3i_pc IN_19 (.D( PAD ), .B( GNDOI ), .G( ng ), .S( GNDOI ));
jio_ne3i_pc IN_20 (.D( PAD ), .B( GNDOI ), .G( ng ), .S( GNDOI ));
jio_ne3i_pc IN_21 (.D( PAD ), .B( GNDOI ), .G( ng ), .S( GNDOI ));
jio_ne3i_pc IN_22 (.D( PAD ), .B( GNDOI ), .G( ng ), .S( GNDOI ));
jio_ne3i_pc IN_23 (.D( PAD ), .B( GNDOI ), .G( ng ), .S( GNDOI ));
jio_ne3i_pc IN_24 (.D( PAD ), .B( GNDOI ), .G( ng ), .S( GNDOI ));
jio_andio_pc I157 (.PSUB( PSUB ), .PWI( GNDOI ), .DNW( VDDOI ));
jio_pe3i_pc IP_1 (.S( VDDOI ), .G( pg ), .B( VDDOI ), .D( PAD ));
jio_pe3i_pc IP_2 (.S( VDDOI ), .G( pg ), .B( VDDOI ), .D( PAD ));
jio_pe3i_pc IP_3 (.S( VDDOI ), .G( pg ), .B( VDDOI ), .D( PAD ));
jio_pe3i_pc IP_4 (.S( VDDOI ), .G( pg ), .B( VDDOI ), .D( PAD ));
jio_pe3i_pc IP_5 (.S( VDDOI ), .G( pg ), .B( VDDOI ), .D( PAD ));
jio_pe3i_pc IP_6 (.S( VDDOI ), .G( pg ), .B( VDDOI ), .D( PAD ));
jio_pe3i_pc IP_7 (.S( VDDOI ), .G( pg ), .B( VDDOI ), .D( PAD ));
jio_pe3i_pc IP_8 (.S( VDDOI ), .G( pg ), .B( VDDOI ), .D( PAD ));
jio_pe3i_pc IP_9 (.S( VDDOI ), .G( pg ), .B( VDDOI ), .D( PAD ));
jio_pe3i_pc IP_10 (.S( VDDOI ), .G( pg ), .B( VDDOI ), .D( PAD ));
jio_pe3i_pc IP_11 (.S( VDDOI ), .G( pg ), .B( VDDOI ), .D( PAD ));
jio_pe3i_pc IP_12 (.S( VDDOI ), .G( pg ), .B( VDDOI ), .D( PAD ));
jio_pe3i_pc IP_13 (.S( VDDOI ), .G( pg ), .B( VDDOI ), .D( PAD ));
jio_pe3i_pc IP_14 (.S( VDDOI ), .G( pg ), .B( VDDOI ), .D( PAD ));
jio_pe3i_pc IP_15 (.S( VDDOI ), .G( pg ), .B( VDDOI ), .D( PAD ));
jio_pe3i_pc IP_16 (.S( VDDOI ), .G( pg ), .B( VDDOI ), .D( PAD ));
jio_pe3i_pc IP_17 (.S( VDDOI ), .G( pg ), .B( VDDOI ), .D( PAD ));
jio_pe3i_pc IP_18 (.S( VDDOI ), .G( pg ), .B( VDDOI ), .D( PAD ));
jio_pe3i_pc IP_19 (.S( VDDOI ), .G( pg ), .B( VDDOI ), .D( PAD ));
jio_pe3i_pc IP_20 (.S( VDDOI ), .G( pg ), .B( VDDOI ), .D( PAD ));
jio_pe3i_pc IP_21 (.S( VDDOI ), .G( pg ), .B( VDDOI ), .D( PAD ));
jio_pe3i_pc IP_22 (.S( VDDOI ), .G( pg ), .B( VDDOI ), .D( PAD ));
jio_pe3i_pc IP_23 (.S( VDDOI ), .G( pg ), .B( VDDOI ), .D( PAD ));
jio_pe3i_pc IP_24 (.S( VDDOI ), .G( pg ), .B( VDDOI ), .D( PAD ));
jio_pe3i_pc IP_25 (.S( VDDOI ), .G( pg ), .B( VDDOI ), .D( PAD ));
jio_pe3i_pc IP_26 (.S( VDDOI ), .G( pg ), .B( VDDOI ), .D( PAD ));
jio_pe3i_pc IP_27 (.S( VDDOI ), .G( pg ), .B( VDDOI ), .D( PAD ));
jio_pe3i_pc IP_28 (.S( VDDOI ), .G( pg ), .B( VDDOI ), .D( PAD ));
jio_pe3i_pc IP_29 (.S( VDDOI ), .G( pg ), .B( VDDOI ), .D( PAD ));
jio_pe3i_pc IP_30 (.S( VDDOI ), .G( pg ), .B( VDDOI ), .D( PAD ));
jio_pe3i_pc IP_31 (.S( VDDOI ), .G( pg ), .B( VDDOI ), .D( PAD ));
jio_pe3i_pc IP_32 (.S( VDDOI ), .G( pg ), .B( VDDOI ), .D( PAD ));
rdp3 #(.l(3.3e-06), .w(4.4e-07), .m(1), .par1(1))
(* integer passed_mfactor = "m"; *)
 R11 (ng, GNDOI, VDDOI);
rdp3 #(.l(3.3e-06), .w(4.4e-07), .m(1), .par1(1))
(* integer passed_mfactor = "m"; *)
 R0 (VDDOI, pg, VDDOI);

endmodule
// Library - IO_CELLS_JIC3V, Cell - jio_pe3i_pc, View - cmos_sch
// LAST TIME SAVED: Nov 16 11:13:44 2021
// NETLIST TIME: Feb  9 05:16:35 2024

`worklib IO_CELLS_JIC3V
`view cmos_sch

`timescale 1ns / 1ps
(* cds_ams_schematic *)

module jio_pe3i_pc (B, D, G, S);
inout  B, D, G, S;
pe3i #(.w(3e-05), .l(3.5e-07), .as(1.44e-11), .ad(1.44e-11), .ps(6.096e-05), .pd(6.096e-05), .nrs(0.009), .nrd(0.009), .m((1)*(1)), .par1((1)*(1)))
(* integer passed_mfactor = "m"; *)
 M0 (net6, G, S, B);
rdp3 #(.l(2.15e-06), .w(3e-05), .m(1), .par1(1))
(* integer passed_mfactor = "m"; *)
 R1 (net6, D, B);

endmodule
// Library - IO_CELLS_JIC3V, Cell - VDDPADPC, View - cmos_sch
// LAST TIME SAVED: Nov 16 11:05:21 2021
// NETLIST TIME: Feb  9 05:16:35 2024

`worklib IO_CELLS_JIC3V
`view cmos_sch

`timescale 1ns / 1ps
(* cds_ams_schematic *)

module VDDPADPC (GNDI, GNDOI, GNDRI, PSUB, VDD3I, VDDOI, VDDRI);
input  GNDI, GNDOI, GNDRI, PSUB, VDD3I, VDDOI, VDDRI;
wire ng;
wire pg;
jio_ne3i_pc IN_1 (.D( VDD3I ), .B( GNDOI ), .G( ng ), .S( GNDOI ));
jio_ne3i_pc IN_2 (.D( VDD3I ), .B( GNDOI ), .G( ng ), .S( GNDOI ));
jio_ne3i_pc IN_3 (.D( VDD3I ), .B( GNDOI ), .G( ng ), .S( GNDOI ));
jio_ne3i_pc IN_4 (.D( VDD3I ), .B( GNDOI ), .G( ng ), .S( GNDOI ));
jio_ne3i_pc IN_5 (.D( VDD3I ), .B( GNDOI ), .G( ng ), .S( GNDOI ));
jio_ne3i_pc IN_6 (.D( VDD3I ), .B( GNDOI ), .G( ng ), .S( GNDOI ));
jio_ne3i_pc IN_7 (.D( VDD3I ), .B( GNDOI ), .G( ng ), .S( GNDOI ));
jio_ne3i_pc IN_8 (.D( VDD3I ), .B( GNDOI ), .G( ng ), .S( GNDOI ));
jio_ne3i_pc IN_9 (.D( VDD3I ), .B( GNDOI ), .G( ng ), .S( GNDOI ));
jio_ne3i_pc IN_10 (.D( VDD3I ), .B( GNDOI ), .G( ng ), .S( GNDOI ));
jio_ne3i_pc IN_11 (.D( VDD3I ), .B( GNDOI ), .G( ng ), .S( GNDOI ));
jio_ne3i_pc IN_12 (.D( VDD3I ), .B( GNDOI ), .G( ng ), .S( GNDOI ));
jio_ne3i_pc IN_13 (.D( VDD3I ), .B( GNDOI ), .G( ng ), .S( GNDOI ));
jio_ne3i_pc IN_14 (.D( VDD3I ), .B( GNDOI ), .G( ng ), .S( GNDOI ));
jio_ne3i_pc IN_15 (.D( VDD3I ), .B( GNDOI ), .G( ng ), .S( GNDOI ));
jio_ne3i_pc IN_16 (.D( VDD3I ), .B( GNDOI ), .G( ng ), .S( GNDOI ));
jio_ne3i_pc IN_17 (.D( VDD3I ), .B( GNDOI ), .G( ng ), .S( GNDOI ));
jio_ne3i_pc IN_18 (.D( VDD3I ), .B( GNDOI ), .G( ng ), .S( GNDOI ));
jio_ne3i_pc IN_19 (.D( VDD3I ), .B( GNDOI ), .G( ng ), .S( GNDOI ));
jio_ne3i_pc IN_20 (.D( VDD3I ), .B( GNDOI ), .G( ng ), .S( GNDOI ));
jio_ne3i_pc IN_21 (.D( VDD3I ), .B( GNDOI ), .G( ng ), .S( GNDOI ));
jio_ne3i_pc IN_22 (.D( VDD3I ), .B( GNDOI ), .G( ng ), .S( GNDOI ));
jio_ne3i_pc IN_23 (.D( VDD3I ), .B( GNDOI ), .G( ng ), .S( GNDOI ));
jio_ne3i_pc IN_24 (.D( VDD3I ), .B( GNDOI ), .G( ng ), .S( GNDOI ));
jio_andio_pc I157 (.DNW( VDDOI ), .PWI( GNDOI ), .PSUB( PSUB ));
jio_pe3i_pc IP_1 (.S( VDDOI ), .G( pg ), .B( VDDOI ), .D( VDD3I ));
jio_pe3i_pc IP_2 (.S( VDDOI ), .G( pg ), .B( VDDOI ), .D( VDD3I ));
jio_pe3i_pc IP_3 (.S( VDDOI ), .G( pg ), .B( VDDOI ), .D( VDD3I ));
jio_pe3i_pc IP_4 (.S( VDDOI ), .G( pg ), .B( VDDOI ), .D( VDD3I ));
jio_pe3i_pc IP_5 (.S( VDDOI ), .G( pg ), .B( VDDOI ), .D( VDD3I ));
jio_pe3i_pc IP_6 (.S( VDDOI ), .G( pg ), .B( VDDOI ), .D( VDD3I ));
jio_pe3i_pc IP_7 (.S( VDDOI ), .G( pg ), .B( VDDOI ), .D( VDD3I ));
jio_pe3i_pc IP_8 (.S( VDDOI ), .G( pg ), .B( VDDOI ), .D( VDD3I ));
jio_pe3i_pc IP_9 (.S( VDDOI ), .G( pg ), .B( VDDOI ), .D( VDD3I ));
jio_pe3i_pc IP_10 (.S( VDDOI ), .G( pg ), .B( VDDOI ), .D( VDD3I ));
jio_pe3i_pc IP_11 (.S( VDDOI ), .G( pg ), .B( VDDOI ), .D( VDD3I ));
jio_pe3i_pc IP_12 (.S( VDDOI ), .G( pg ), .B( VDDOI ), .D( VDD3I ));
jio_pe3i_pc IP_13 (.S( VDDOI ), .G( pg ), .B( VDDOI ), .D( VDD3I ));
jio_pe3i_pc IP_14 (.S( VDDOI ), .G( pg ), .B( VDDOI ), .D( VDD3I ));
jio_pe3i_pc IP_15 (.S( VDDOI ), .G( pg ), .B( VDDOI ), .D( VDD3I ));
jio_pe3i_pc IP_16 (.S( VDDOI ), .G( pg ), .B( VDDOI ), .D( VDD3I ));
jio_pe3i_pc IP_17 (.S( VDDOI ), .G( pg ), .B( VDDOI ), .D( VDD3I ));
jio_pe3i_pc IP_18 (.S( VDDOI ), .G( pg ), .B( VDDOI ), .D( VDD3I ));
jio_pe3i_pc IP_19 (.S( VDDOI ), .G( pg ), .B( VDDOI ), .D( VDD3I ));
jio_pe3i_pc IP_20 (.S( VDDOI ), .G( pg ), .B( VDDOI ), .D( VDD3I ));
jio_pe3i_pc IP_21 (.S( VDDOI ), .G( pg ), .B( VDDOI ), .D( VDD3I ));
jio_pe3i_pc IP_22 (.S( VDDOI ), .G( pg ), .B( VDDOI ), .D( VDD3I ));
jio_pe3i_pc IP_23 (.S( VDDOI ), .G( pg ), .B( VDDOI ), .D( VDD3I ));
jio_pe3i_pc IP_24 (.S( VDDOI ), .G( pg ), .B( VDDOI ), .D( VDD3I ));
jio_pe3i_pc IP_25 (.S( VDDOI ), .G( pg ), .B( VDDOI ), .D( VDD3I ));
jio_pe3i_pc IP_26 (.S( VDDOI ), .G( pg ), .B( VDDOI ), .D( VDD3I ));
jio_pe3i_pc IP_27 (.S( VDDOI ), .G( pg ), .B( VDDOI ), .D( VDD3I ));
jio_pe3i_pc IP_28 (.S( VDDOI ), .G( pg ), .B( VDDOI ), .D( VDD3I ));
jio_pe3i_pc IP_29 (.S( VDDOI ), .G( pg ), .B( VDDOI ), .D( VDD3I ));
jio_pe3i_pc IP_30 (.S( VDDOI ), .G( pg ), .B( VDDOI ), .D( VDD3I ));
jio_pe3i_pc IP_31 (.S( VDDOI ), .G( pg ), .B( VDDOI ), .D( VDD3I ));
jio_pe3i_pc IP_32 (.S( VDDOI ), .G( pg ), .B( VDDOI ), .D( VDD3I ));
rdp3 #(.l(3.3e-06), .w(4.4e-07), .m(1), .par1(1))
(* integer passed_mfactor = "m"; *)
 R0 (VDDOI, pg, VDDOI);
rdp3 #(.l(3.3e-06), .w(4.4e-07), .m(1), .par1(1))
(* integer passed_mfactor = "m"; *)
 R11 (ng, GNDOI, VDDOI);

endmodule
// Library - IO_CELLS_JIC3V, Cell - GNDORPADPC, View - cmos_sch
// LAST TIME SAVED: Nov 16 11:00:05 2021
// NETLIST TIME: Feb  9 05:16:35 2024

`worklib IO_CELLS_JIC3V
`view cmos_sch

`timescale 1ns / 1ps
(* cds_ams_schematic *)

module GNDORPADPC (GNDI, GNDORI, PSUB, VDD3I, VDDOI, VDDRI);
input  GNDI, GNDORI, PSUB, VDD3I, VDDOI, VDDRI;
wire ng;
jio_ne3i_pc IN_1 (.D( VDDOI ), .B( GNDORI ), .G( ng ), .S( GNDORI ));
jio_ne3i_pc IN_2 (.D( VDDOI ), .B( GNDORI ), .G( ng ), .S( GNDORI ));
jio_ne3i_pc IN_3 (.D( VDDOI ), .B( GNDORI ), .G( ng ), .S( GNDORI ));
jio_ne3i_pc IN_4 (.D( VDDOI ), .B( GNDORI ), .G( ng ), .S( GNDORI ));
jio_ne3i_pc IN_5 (.D( VDDOI ), .B( GNDORI ), .G( ng ), .S( GNDORI ));
jio_ne3i_pc IN_6 (.D( VDDOI ), .B( GNDORI ), .G( ng ), .S( GNDORI ));
jio_ne3i_pc IN_7 (.D( VDDOI ), .B( GNDORI ), .G( ng ), .S( GNDORI ));
jio_ne3i_pc IN_8 (.D( VDDOI ), .B( GNDORI ), .G( ng ), .S( GNDORI ));
jio_ne3i_pc IN_9 (.D( VDDOI ), .B( GNDORI ), .G( ng ), .S( GNDORI ));
jio_ne3i_pc IN_10 (.D( VDDOI ), .B( GNDORI ), .G( ng ), .S( GNDORI ));
jio_ne3i_pc IN_11 (.D( VDDOI ), .B( GNDORI ), .G( ng ), .S( GNDORI ));
jio_ne3i_pc IN_12 (.D( VDDOI ), .B( GNDORI ), .G( ng ), .S( GNDORI ));
jio_ne3i_pc IN_13 (.D( VDDOI ), .B( GNDORI ), .G( ng ), .S( GNDORI ));
jio_ne3i_pc IN_14 (.D( VDDOI ), .B( GNDORI ), .G( ng ), .S( GNDORI ));
jio_ne3i_pc IN_15 (.D( VDDOI ), .B( GNDORI ), .G( ng ), .S( GNDORI ));
jio_ne3i_pc IN_16 (.D( VDDOI ), .B( GNDORI ), .G( ng ), .S( GNDORI ));
jio_ne3i_pc IN_17 (.D( VDDOI ), .B( GNDORI ), .G( ng ), .S( GNDORI ));
jio_ne3i_pc IN_18 (.D( VDDOI ), .B( GNDORI ), .G( ng ), .S( GNDORI ));
jio_ne3i_pc IN_19 (.D( VDDOI ), .B( GNDORI ), .G( ng ), .S( GNDORI ));
jio_ne3i_pc IN_20 (.D( VDDOI ), .B( GNDORI ), .G( ng ), .S( GNDORI ));
jio_ne3i_pc IN_21 (.D( VDDOI ), .B( GNDORI ), .G( ng ), .S( GNDORI ));
jio_ne3i_pc IN_22 (.D( VDDOI ), .B( GNDORI ), .G( ng ), .S( GNDORI ));
jio_ne3i_pc IN_23 (.D( VDDOI ), .B( GNDORI ), .G( ng ), .S( GNDORI ));
jio_ne3i_pc IN_24 (.D( VDDOI ), .B( GNDORI ), .G( ng ), .S( GNDORI ));
jio_andio_pc I157 (.DNW( VDDOI ), .PWI( GNDORI ), .PSUB( PSUB ));
rdp3 #(.l(3.3e-06), .w(4.4e-07), .m(1), .par1(1))
(* integer passed_mfactor = "m"; *)
 R11 (ng, GNDORI, VDDOI);

endmodule
// Library - IO_CELLS_JIC3V, Cell - PSUBPADPC, View - cmos_sch
// LAST TIME SAVED: Nov 16 11:01:31 2021
// NETLIST TIME: Feb  9 05:16:35 2024

`worklib IO_CELLS_JIC3V
`view cmos_sch

`timescale 1ns / 1ps
(* cds_ams_schematic *)

module PSUBPADPC (GNDI, GNDOI, GNDRI, PSUB, VDD3I, VDDOI, VDDRI);
input  GNDI, GNDOI, GNDRI, PSUB, VDD3I, VDDOI, VDDRI;
wire pg;
wire ng;
jio_pe3i_pc IP_1 (.S( VDDOI ), .G( pg ), .B( VDDOI ), .D( PSUB ));
jio_pe3i_pc IP_2 (.S( VDDOI ), .G( pg ), .B( VDDOI ), .D( PSUB ));
jio_pe3i_pc IP_3 (.S( VDDOI ), .G( pg ), .B( VDDOI ), .D( PSUB ));
jio_pe3i_pc IP_4 (.S( VDDOI ), .G( pg ), .B( VDDOI ), .D( PSUB ));
jio_pe3i_pc IP_5 (.S( VDDOI ), .G( pg ), .B( VDDOI ), .D( PSUB ));
jio_pe3i_pc IP_6 (.S( VDDOI ), .G( pg ), .B( VDDOI ), .D( PSUB ));
jio_pe3i_pc IP_7 (.S( VDDOI ), .G( pg ), .B( VDDOI ), .D( PSUB ));
jio_pe3i_pc IP_8 (.S( VDDOI ), .G( pg ), .B( VDDOI ), .D( PSUB ));
jio_pe3i_pc IP_9 (.S( VDDOI ), .G( pg ), .B( VDDOI ), .D( PSUB ));
jio_pe3i_pc IP_10 (.S( VDDOI ), .G( pg ), .B( VDDOI ), .D( PSUB ));
jio_pe3i_pc IP_11 (.S( VDDOI ), .G( pg ), .B( VDDOI ), .D( PSUB ));
jio_pe3i_pc IP_12 (.S( VDDOI ), .G( pg ), .B( VDDOI ), .D( PSUB ));
jio_pe3i_pc IP_13 (.S( VDDOI ), .G( pg ), .B( VDDOI ), .D( PSUB ));
jio_pe3i_pc IP_14 (.S( VDDOI ), .G( pg ), .B( VDDOI ), .D( PSUB ));
jio_pe3i_pc IP_15 (.S( VDDOI ), .G( pg ), .B( VDDOI ), .D( PSUB ));
jio_pe3i_pc IP_16 (.S( VDDOI ), .G( pg ), .B( VDDOI ), .D( PSUB ));
jio_pe3i_pc IP_17 (.S( VDDOI ), .G( pg ), .B( VDDOI ), .D( PSUB ));
jio_pe3i_pc IP_18 (.S( VDDOI ), .G( pg ), .B( VDDOI ), .D( PSUB ));
jio_pe3i_pc IP_19 (.S( VDDOI ), .G( pg ), .B( VDDOI ), .D( PSUB ));
jio_pe3i_pc IP_20 (.S( VDDOI ), .G( pg ), .B( VDDOI ), .D( PSUB ));
jio_pe3i_pc IP_21 (.S( VDDOI ), .G( pg ), .B( VDDOI ), .D( PSUB ));
jio_pe3i_pc IP_22 (.S( VDDOI ), .G( pg ), .B( VDDOI ), .D( PSUB ));
jio_pe3i_pc IP_23 (.S( VDDOI ), .G( pg ), .B( VDDOI ), .D( PSUB ));
jio_pe3i_pc IP_24 (.S( VDDOI ), .G( pg ), .B( VDDOI ), .D( PSUB ));
jio_pe3i_pc IP_25 (.S( VDDOI ), .G( pg ), .B( VDDOI ), .D( PSUB ));
jio_pe3i_pc IP_26 (.S( VDDOI ), .G( pg ), .B( VDDOI ), .D( PSUB ));
jio_pe3i_pc IP_27 (.S( VDDOI ), .G( pg ), .B( VDDOI ), .D( PSUB ));
jio_pe3i_pc IP_28 (.S( VDDOI ), .G( pg ), .B( VDDOI ), .D( PSUB ));
jio_pe3i_pc IP_29 (.S( VDDOI ), .G( pg ), .B( VDDOI ), .D( PSUB ));
jio_pe3i_pc IP_30 (.S( VDDOI ), .G( pg ), .B( VDDOI ), .D( PSUB ));
jio_pe3i_pc IP_31 (.S( VDDOI ), .G( pg ), .B( VDDOI ), .D( PSUB ));
jio_pe3i_pc IP_32 (.S( VDDOI ), .G( pg ), .B( VDDOI ), .D( PSUB ));
jio_ne3i_pc IN_1 (.D( GNDOI ), .B( PSUB ), .G( ng ), .S( PSUB ));
jio_ne3i_pc IN_2 (.D( GNDOI ), .B( PSUB ), .G( ng ), .S( PSUB ));
jio_ne3i_pc IN_3 (.D( GNDOI ), .B( PSUB ), .G( ng ), .S( PSUB ));
jio_ne3i_pc IN_4 (.D( GNDOI ), .B( PSUB ), .G( ng ), .S( PSUB ));
jio_ne3i_pc IN_5 (.D( GNDOI ), .B( PSUB ), .G( ng ), .S( PSUB ));
jio_ne3i_pc IN_6 (.D( GNDOI ), .B( PSUB ), .G( ng ), .S( PSUB ));
jio_ne3i_pc IN_7 (.D( GNDOI ), .B( PSUB ), .G( ng ), .S( PSUB ));
jio_ne3i_pc IN_8 (.D( GNDOI ), .B( PSUB ), .G( ng ), .S( PSUB ));
jio_ne3i_pc IN_9 (.D( GNDOI ), .B( PSUB ), .G( ng ), .S( PSUB ));
jio_ne3i_pc IN_10 (.D( GNDOI ), .B( PSUB ), .G( ng ), .S( PSUB ));
jio_ne3i_pc IN_11 (.D( GNDOI ), .B( PSUB ), .G( ng ), .S( PSUB ));
jio_ne3i_pc IN_12 (.D( GNDOI ), .B( PSUB ), .G( ng ), .S( PSUB ));
jio_ne3i_pc IN_13 (.D( GNDOI ), .B( PSUB ), .G( ng ), .S( PSUB ));
jio_ne3i_pc IN_14 (.D( GNDOI ), .B( PSUB ), .G( ng ), .S( PSUB ));
jio_ne3i_pc IN_15 (.D( GNDOI ), .B( PSUB ), .G( ng ), .S( PSUB ));
jio_ne3i_pc IN_16 (.D( GNDOI ), .B( PSUB ), .G( ng ), .S( PSUB ));
jio_ne3i_pc IN_17 (.D( GNDOI ), .B( PSUB ), .G( ng ), .S( PSUB ));
jio_ne3i_pc IN_18 (.D( GNDOI ), .B( PSUB ), .G( ng ), .S( PSUB ));
jio_ne3i_pc IN_19 (.D( GNDOI ), .B( PSUB ), .G( ng ), .S( PSUB ));
jio_ne3i_pc IN_20 (.D( GNDOI ), .B( PSUB ), .G( ng ), .S( PSUB ));
jio_ne3i_pc IN_21 (.D( GNDOI ), .B( PSUB ), .G( ng ), .S( PSUB ));
jio_ne3i_pc IN_22 (.D( GNDOI ), .B( PSUB ), .G( ng ), .S( PSUB ));
jio_ne3i_pc IN_23 (.D( GNDOI ), .B( PSUB ), .G( ng ), .S( PSUB ));
jio_ne3i_pc IN_24 (.D( GNDOI ), .B( PSUB ), .G( ng ), .S( PSUB ));
jio_andio_pc I157 (.PSUB( PSUB ), .PWI( PSUB ), .DNW( GNDOI ));
rdp3 #(.l(3.3e-06), .w(4.4e-07), .m(1), .par1(1))
(* integer passed_mfactor = "m"; *)
 R11 (ng, PSUB, VDDOI);
rdp3 #(.l(3.3e-06), .w(4.4e-07), .m(1), .par1(1))
(* integer passed_mfactor = "m"; *)
 R0 (VDDOI, pg, VDDOI);

endmodule
// Library - IO_CELLS_JIC3V, Cell - GNDPADPC, View - cmos_sch
// LAST TIME SAVED: Nov 16 11:00:33 2021
// NETLIST TIME: Feb  9 05:16:35 2024

`worklib IO_CELLS_JIC3V
`view cmos_sch

`timescale 1ns / 1ps
(* cds_ams_schematic *)

module GNDPADPC (GNDI, GNDOI, GNDRI, PSUB, VDD3I, VDDOI, VDDRI);
input  GNDI, GNDOI, GNDRI, PSUB, VDD3I, VDDOI, VDDRI;
wire ng;
wire pg;
jio_ne3i_pc IN_1 (.D( GNDI ), .B( GNDOI ), .G( ng ), .S( GNDOI ));
jio_ne3i_pc IN_2 (.D( GNDI ), .B( GNDOI ), .G( ng ), .S( GNDOI ));
jio_ne3i_pc IN_3 (.D( GNDI ), .B( GNDOI ), .G( ng ), .S( GNDOI ));
jio_ne3i_pc IN_4 (.D( GNDI ), .B( GNDOI ), .G( ng ), .S( GNDOI ));
jio_ne3i_pc IN_5 (.D( GNDI ), .B( GNDOI ), .G( ng ), .S( GNDOI ));
jio_ne3i_pc IN_6 (.D( GNDI ), .B( GNDOI ), .G( ng ), .S( GNDOI ));
jio_ne3i_pc IN_7 (.D( GNDI ), .B( GNDOI ), .G( ng ), .S( GNDOI ));
jio_ne3i_pc IN_8 (.D( GNDI ), .B( GNDOI ), .G( ng ), .S( GNDOI ));
jio_ne3i_pc IN_9 (.D( GNDI ), .B( GNDOI ), .G( ng ), .S( GNDOI ));
jio_ne3i_pc IN_10 (.D( GNDI ), .B( GNDOI ), .G( ng ), .S( GNDOI ));
jio_ne3i_pc IN_11 (.D( GNDI ), .B( GNDOI ), .G( ng ), .S( GNDOI ));
jio_ne3i_pc IN_12 (.D( GNDI ), .B( GNDOI ), .G( ng ), .S( GNDOI ));
jio_ne3i_pc IN_13 (.D( GNDI ), .B( GNDOI ), .G( ng ), .S( GNDOI ));
jio_ne3i_pc IN_14 (.D( GNDI ), .B( GNDOI ), .G( ng ), .S( GNDOI ));
jio_ne3i_pc IN_15 (.D( GNDI ), .B( GNDOI ), .G( ng ), .S( GNDOI ));
jio_ne3i_pc IN_16 (.D( GNDI ), .B( GNDOI ), .G( ng ), .S( GNDOI ));
jio_ne3i_pc IN_17 (.D( GNDI ), .B( GNDOI ), .G( ng ), .S( GNDOI ));
jio_ne3i_pc IN_18 (.D( GNDI ), .B( GNDOI ), .G( ng ), .S( GNDOI ));
jio_ne3i_pc IN_19 (.D( GNDI ), .B( GNDOI ), .G( ng ), .S( GNDOI ));
jio_ne3i_pc IN_20 (.D( GNDI ), .B( GNDOI ), .G( ng ), .S( GNDOI ));
jio_ne3i_pc IN_21 (.D( GNDI ), .B( GNDOI ), .G( ng ), .S( GNDOI ));
jio_ne3i_pc IN_22 (.D( GNDI ), .B( GNDOI ), .G( ng ), .S( GNDOI ));
jio_ne3i_pc IN_23 (.D( GNDI ), .B( GNDOI ), .G( ng ), .S( GNDOI ));
jio_ne3i_pc IN_24 (.D( GNDI ), .B( GNDOI ), .G( ng ), .S( GNDOI ));
jio_andio_pc I157 (.DNW( VDDOI ), .PWI( GNDOI ), .PSUB( PSUB ));
jio_pe3i_pc IP_1 (.S( VDDOI ), .G( pg ), .B( VDDOI ), .D( GNDI ));
jio_pe3i_pc IP_2 (.S( VDDOI ), .G( pg ), .B( VDDOI ), .D( GNDI ));
jio_pe3i_pc IP_3 (.S( VDDOI ), .G( pg ), .B( VDDOI ), .D( GNDI ));
jio_pe3i_pc IP_4 (.S( VDDOI ), .G( pg ), .B( VDDOI ), .D( GNDI ));
jio_pe3i_pc IP_5 (.S( VDDOI ), .G( pg ), .B( VDDOI ), .D( GNDI ));
jio_pe3i_pc IP_6 (.S( VDDOI ), .G( pg ), .B( VDDOI ), .D( GNDI ));
jio_pe3i_pc IP_7 (.S( VDDOI ), .G( pg ), .B( VDDOI ), .D( GNDI ));
jio_pe3i_pc IP_8 (.S( VDDOI ), .G( pg ), .B( VDDOI ), .D( GNDI ));
jio_pe3i_pc IP_9 (.S( VDDOI ), .G( pg ), .B( VDDOI ), .D( GNDI ));
jio_pe3i_pc IP_10 (.S( VDDOI ), .G( pg ), .B( VDDOI ), .D( GNDI ));
jio_pe3i_pc IP_11 (.S( VDDOI ), .G( pg ), .B( VDDOI ), .D( GNDI ));
jio_pe3i_pc IP_12 (.S( VDDOI ), .G( pg ), .B( VDDOI ), .D( GNDI ));
jio_pe3i_pc IP_13 (.S( VDDOI ), .G( pg ), .B( VDDOI ), .D( GNDI ));
jio_pe3i_pc IP_14 (.S( VDDOI ), .G( pg ), .B( VDDOI ), .D( GNDI ));
jio_pe3i_pc IP_15 (.S( VDDOI ), .G( pg ), .B( VDDOI ), .D( GNDI ));
jio_pe3i_pc IP_16 (.S( VDDOI ), .G( pg ), .B( VDDOI ), .D( GNDI ));
jio_pe3i_pc IP_17 (.S( VDDOI ), .G( pg ), .B( VDDOI ), .D( GNDI ));
jio_pe3i_pc IP_18 (.S( VDDOI ), .G( pg ), .B( VDDOI ), .D( GNDI ));
jio_pe3i_pc IP_19 (.S( VDDOI ), .G( pg ), .B( VDDOI ), .D( GNDI ));
jio_pe3i_pc IP_20 (.S( VDDOI ), .G( pg ), .B( VDDOI ), .D( GNDI ));
jio_pe3i_pc IP_21 (.S( VDDOI ), .G( pg ), .B( VDDOI ), .D( GNDI ));
jio_pe3i_pc IP_22 (.S( VDDOI ), .G( pg ), .B( VDDOI ), .D( GNDI ));
jio_pe3i_pc IP_23 (.S( VDDOI ), .G( pg ), .B( VDDOI ), .D( GNDI ));
jio_pe3i_pc IP_24 (.S( VDDOI ), .G( pg ), .B( VDDOI ), .D( GNDI ));
jio_pe3i_pc IP_25 (.S( VDDOI ), .G( pg ), .B( VDDOI ), .D( GNDI ));
jio_pe3i_pc IP_26 (.S( VDDOI ), .G( pg ), .B( VDDOI ), .D( GNDI ));
jio_pe3i_pc IP_27 (.S( VDDOI ), .G( pg ), .B( VDDOI ), .D( GNDI ));
jio_pe3i_pc IP_28 (.S( VDDOI ), .G( pg ), .B( VDDOI ), .D( GNDI ));
jio_pe3i_pc IP_29 (.S( VDDOI ), .G( pg ), .B( VDDOI ), .D( GNDI ));
jio_pe3i_pc IP_30 (.S( VDDOI ), .G( pg ), .B( VDDOI ), .D( GNDI ));
jio_pe3i_pc IP_31 (.S( VDDOI ), .G( pg ), .B( VDDOI ), .D( GNDI ));
jio_pe3i_pc IP_32 (.S( VDDOI ), .G( pg ), .B( VDDOI ), .D( GNDI ));
rdp3 #(.l(3.3e-06), .w(4.4e-07), .m(1), .par1(1))
(* integer passed_mfactor = "m"; *)
 R0 (VDDOI, pg, VDDOI);
rdp3 #(.l(3.3e-06), .w(4.4e-07), .m(1), .par1(1))
(* integer passed_mfactor = "m"; *)
 R11 (ng, GNDOI, VDDOI);

endmodule
// Library - IO_CELLS_JIC3V, Cell - jio_ipdio_pc, View - cmos_sch
// LAST TIME SAVED: Nov 16 02:00:19 2021
// NETLIST TIME: Feb  9 05:16:35 2024

`worklib IO_CELLS_JIC3V
`view cmos_sch

`timescale 1ns / 1ps
(* cds_ams_schematic *)

module jio_ipdio_pc (DNWR, PSUB, PWIR);
input  DNWR, PSUB, PWIR;
ddnwmv #(.area(3.7825e-10), .perimeter(8.026e-05), .dbv(0), .m(1), .par1(1), .xf_subext(0))
(* integer passed_mfactor = "m"; *)
 D10 (PSUB, DNWR);
dipdnwmv #(.area(1.3272e-10), .perimeter(5.464e-05), .dbv(0), .m(1), .par1(1))
(* integer passed_mfactor = "m"; *)
 D9 (PWIR, DNWR);

endmodule
// Library - IO_CELLS_JIC3V, Cell - jio_lviodio_pc, View - cmos_sch
// LAST TIME SAVED: Nov 16 02:00:18 2021
// NETLIST TIME: Feb  9 05:16:35 2024

`worklib IO_CELLS_JIC3V
`view cmos_sch

`timescale 1ns / 1ps
(* cds_ams_schematic *)

module jio_lviodio_pc (DNLW, LPWI, PSUB);
input  DNLW, LPWI, PSUB;
dipdnwmv #(.area(3.2452e-10), .perimeter(0.00013264), .dbv(0), .m(1), .par1(1))
(* integer passed_mfactor = "m"; *)
 D2 (LPWI, DNLW);

endmodule
// Library - HV_CELLS, Cell - ioh_dhpw_2x100, View - schematic
// LAST TIME SAVED: Feb 25 05:55:51 2015
// NETLIST TIME: Feb  9 05:16:35 2024

`worklib HV_CELLS
`view schematic

`timescale 1ns / 1ps
(* cds_ams_schematic *)

module ioh_dhpw_2x100 (A, K, Sub);
inout  A, K, Sub;
ddnw #(.area(3.37852e-09), .perimeter(0.0002844), .dbv(0), .m(1), .par1(1), .xf_subext(0))
(* integer passed_mfactor = "m"; *)
 D0 (Sub, K);
dhpw #(.area(3.87893e-10), .perimeter(0.000207812), .dbv(0), .m(2), .par1(2))
(* integer passed_mfactor = "m"; *)
 D1 (A, K);

endmodule
// Library - HV_CELLS, Cell - ioh_dhpw_2x100_stack3, View - schematic
// LAST TIME SAVED: Feb 25 05:55:51 2015
// NETLIST TIME: Feb  9 05:16:35 2024

`worklib HV_CELLS
`view schematic

`timescale 1ns / 1ps
(* cds_ams_schematic *)

module ioh_dhpw_2x100_stack3 (A_l, K_h, Sub);
inout  A_l, K_h, Sub;
wire net20;
wire net14;
ioh_dhpw_2x100 I0 (.A( A_l ), .K( net20 ), .Sub( Sub ));
ioh_dhpw_2x100 I2 (.A( net14 ), .K( K_h ), .Sub( Sub ));
ioh_dhpw_2x100 I1 (.A( net20 ), .K( net14 ), .Sub( Sub ));

endmodule
// Library - HV_CELLS, Cell - ioh_pmbsab_40_10, View - schematic
// LAST TIME SAVED: Feb 25 05:55:57 2015
// NETLIST TIME: Feb  9 05:16:35 2024

`worklib HV_CELLS
`view schematic

`timescale 1ns / 1ps
(* cds_ams_schematic *)

module ioh_pmbsab_40_10 (B, D, G, S);
inout  B, D, G, S;
pmb #(.w(4.012e-05), .l(1e-06), .as(1.92576e-11), .ad(1.92576e-11), .ps(8.12e-05), .pd(8.12e-05), .nrs(0.00672981), .nrd(0.00672981), .m((1)*(1)), .par1((1)*(1)))
(* integer passed_mfactor = "m"; *)
 MPX (D, G, S, B);

endmodule
// Library - HV_CELLS, Cell - ioh_pmbsabhv_2000, View - schematic
// LAST TIME SAVED: Feb 25 05:55:57 2015
// NETLIST TIME: Feb  9 05:16:35 2024

`worklib HV_CELLS
`view schematic

`timescale 1ns / 1ps
(* cds_ams_schematic *)

module ioh_pmbsabhv_2000 (D, GSB, Sub);
inout  D, GSB, Sub;
wire [0:49] net20;
ioh_pmbsab_40_10 MP_1 (.D( net20[0] ), .B( GSB ), .G( GSB ), .S( GSB ));
ioh_pmbsab_40_10 MP_2 (.D( net20[1] ), .B( GSB ), .G( GSB ), .S( GSB ));
ioh_pmbsab_40_10 MP_3 (.D( net20[2] ), .B( GSB ), .G( GSB ), .S( GSB ));
ioh_pmbsab_40_10 MP_4 (.D( net20[3] ), .B( GSB ), .G( GSB ), .S( GSB ));
ioh_pmbsab_40_10 MP_5 (.D( net20[4] ), .B( GSB ), .G( GSB ), .S( GSB ));
ioh_pmbsab_40_10 MP_6 (.D( net20[5] ), .B( GSB ), .G( GSB ), .S( GSB ));
ioh_pmbsab_40_10 MP_7 (.D( net20[6] ), .B( GSB ), .G( GSB ), .S( GSB ));
ioh_pmbsab_40_10 MP_8 (.D( net20[7] ), .B( GSB ), .G( GSB ), .S( GSB ));
ioh_pmbsab_40_10 MP_9 (.D( net20[8] ), .B( GSB ), .G( GSB ), .S( GSB ));
ioh_pmbsab_40_10 MP_10 (.D( net20[9] ), .B( GSB ), .G( GSB ), .S( GSB ));
ioh_pmbsab_40_10 MP_11 (.D( net20[10] ), .B( GSB ), .G( GSB ), .S( GSB ));
ioh_pmbsab_40_10 MP_12 (.D( net20[11] ), .B( GSB ), .G( GSB ), .S( GSB ));
ioh_pmbsab_40_10 MP_13 (.D( net20[12] ), .B( GSB ), .G( GSB ), .S( GSB ));
ioh_pmbsab_40_10 MP_14 (.D( net20[13] ), .B( GSB ), .G( GSB ), .S( GSB ));
ioh_pmbsab_40_10 MP_15 (.D( net20[14] ), .B( GSB ), .G( GSB ), .S( GSB ));
ioh_pmbsab_40_10 MP_16 (.D( net20[15] ), .B( GSB ), .G( GSB ), .S( GSB ));
ioh_pmbsab_40_10 MP_17 (.D( net20[16] ), .B( GSB ), .G( GSB ), .S( GSB ));
ioh_pmbsab_40_10 MP_18 (.D( net20[17] ), .B( GSB ), .G( GSB ), .S( GSB ));
ioh_pmbsab_40_10 MP_19 (.D( net20[18] ), .B( GSB ), .G( GSB ), .S( GSB ));
ioh_pmbsab_40_10 MP_20 (.D( net20[19] ), .B( GSB ), .G( GSB ), .S( GSB ));
ioh_pmbsab_40_10 MP_21 (.D( net20[20] ), .B( GSB ), .G( GSB ), .S( GSB ));
ioh_pmbsab_40_10 MP_22 (.D( net20[21] ), .B( GSB ), .G( GSB ), .S( GSB ));
ioh_pmbsab_40_10 MP_23 (.D( net20[22] ), .B( GSB ), .G( GSB ), .S( GSB ));
ioh_pmbsab_40_10 MP_24 (.D( net20[23] ), .B( GSB ), .G( GSB ), .S( GSB ));
ioh_pmbsab_40_10 MP_25 (.D( net20[24] ), .B( GSB ), .G( GSB ), .S( GSB ));
ioh_pmbsab_40_10 MP_26 (.D( net20[25] ), .B( GSB ), .G( GSB ), .S( GSB ));
ioh_pmbsab_40_10 MP_27 (.D( net20[26] ), .B( GSB ), .G( GSB ), .S( GSB ));
ioh_pmbsab_40_10 MP_28 (.D( net20[27] ), .B( GSB ), .G( GSB ), .S( GSB ));
ioh_pmbsab_40_10 MP_29 (.D( net20[28] ), .B( GSB ), .G( GSB ), .S( GSB ));
ioh_pmbsab_40_10 MP_30 (.D( net20[29] ), .B( GSB ), .G( GSB ), .S( GSB ));
ioh_pmbsab_40_10 MP_31 (.D( net20[30] ), .B( GSB ), .G( GSB ), .S( GSB ));
ioh_pmbsab_40_10 MP_32 (.D( net20[31] ), .B( GSB ), .G( GSB ), .S( GSB ));
ioh_pmbsab_40_10 MP_33 (.D( net20[32] ), .B( GSB ), .G( GSB ), .S( GSB ));
ioh_pmbsab_40_10 MP_34 (.D( net20[33] ), .B( GSB ), .G( GSB ), .S( GSB ));
ioh_pmbsab_40_10 MP_35 (.D( net20[34] ), .B( GSB ), .G( GSB ), .S( GSB ));
ioh_pmbsab_40_10 MP_36 (.D( net20[35] ), .B( GSB ), .G( GSB ), .S( GSB ));
ioh_pmbsab_40_10 MP_37 (.D( net20[36] ), .B( GSB ), .G( GSB ), .S( GSB ));
ioh_pmbsab_40_10 MP_38 (.D( net20[37] ), .B( GSB ), .G( GSB ), .S( GSB ));
ioh_pmbsab_40_10 MP_39 (.D( net20[38] ), .B( GSB ), .G( GSB ), .S( GSB ));
ioh_pmbsab_40_10 MP_40 (.D( net20[39] ), .B( GSB ), .G( GSB ), .S( GSB ));
ioh_pmbsab_40_10 MP_41 (.D( net20[40] ), .B( GSB ), .G( GSB ), .S( GSB ));
ioh_pmbsab_40_10 MP_42 (.D( net20[41] ), .B( GSB ), .G( GSB ), .S( GSB ));
ioh_pmbsab_40_10 MP_43 (.D( net20[42] ), .B( GSB ), .G( GSB ), .S( GSB ));
ioh_pmbsab_40_10 MP_44 (.D( net20[43] ), .B( GSB ), .G( GSB ), .S( GSB ));
ioh_pmbsab_40_10 MP_45 (.D( net20[44] ), .B( GSB ), .G( GSB ), .S( GSB ));
ioh_pmbsab_40_10 MP_46 (.D( net20[45] ), .B( GSB ), .G( GSB ), .S( GSB ));
ioh_pmbsab_40_10 MP_47 (.D( net20[46] ), .B( GSB ), .G( GSB ), .S( GSB ));
ioh_pmbsab_40_10 MP_48 (.D( net20[47] ), .B( GSB ), .G( GSB ), .S( GSB ));
ioh_pmbsab_40_10 MP_49 (.D( net20[48] ), .B( GSB ), .G( GSB ), .S( GSB ));
ioh_pmbsab_40_10 MP_50 (.D( net20[49] ), .B( GSB ), .G( GSB ), .S( GSB ));
rdp_io #(.l(5.1e-07), .w(4e-05), .m(1), .par1(1), .xf_subext(0))
(* integer passed_mfactor = "m"; *)
 R0_1 (net20[0], D, GSB);
rdp_io #(.l(5.1e-07), .w(4e-05), .m(1), .par1(1), .xf_subext(0))
(* integer passed_mfactor = "m"; *)
 R0_2 (net20[1], D, GSB);
rdp_io #(.l(5.1e-07), .w(4e-05), .m(1), .par1(1), .xf_subext(0))
(* integer passed_mfactor = "m"; *)
 R0_3 (net20[2], D, GSB);
rdp_io #(.l(5.1e-07), .w(4e-05), .m(1), .par1(1), .xf_subext(0))
(* integer passed_mfactor = "m"; *)
 R0_4 (net20[3], D, GSB);
rdp_io #(.l(5.1e-07), .w(4e-05), .m(1), .par1(1), .xf_subext(0))
(* integer passed_mfactor = "m"; *)
 R0_5 (net20[4], D, GSB);
rdp_io #(.l(5.1e-07), .w(4e-05), .m(1), .par1(1), .xf_subext(0))
(* integer passed_mfactor = "m"; *)
 R0_6 (net20[5], D, GSB);
rdp_io #(.l(5.1e-07), .w(4e-05), .m(1), .par1(1), .xf_subext(0))
(* integer passed_mfactor = "m"; *)
 R0_7 (net20[6], D, GSB);
rdp_io #(.l(5.1e-07), .w(4e-05), .m(1), .par1(1), .xf_subext(0))
(* integer passed_mfactor = "m"; *)
 R0_8 (net20[7], D, GSB);
rdp_io #(.l(5.1e-07), .w(4e-05), .m(1), .par1(1), .xf_subext(0))
(* integer passed_mfactor = "m"; *)
 R0_9 (net20[8], D, GSB);
rdp_io #(.l(5.1e-07), .w(4e-05), .m(1), .par1(1), .xf_subext(0))
(* integer passed_mfactor = "m"; *)
 R0_10 (net20[9], D, GSB);
rdp_io #(.l(5.1e-07), .w(4e-05), .m(1), .par1(1), .xf_subext(0))
(* integer passed_mfactor = "m"; *)
 R0_11 (net20[10], D, GSB);
rdp_io #(.l(5.1e-07), .w(4e-05), .m(1), .par1(1), .xf_subext(0))
(* integer passed_mfactor = "m"; *)
 R0_12 (net20[11], D, GSB);
rdp_io #(.l(5.1e-07), .w(4e-05), .m(1), .par1(1), .xf_subext(0))
(* integer passed_mfactor = "m"; *)
 R0_13 (net20[12], D, GSB);
rdp_io #(.l(5.1e-07), .w(4e-05), .m(1), .par1(1), .xf_subext(0))
(* integer passed_mfactor = "m"; *)
 R0_14 (net20[13], D, GSB);
rdp_io #(.l(5.1e-07), .w(4e-05), .m(1), .par1(1), .xf_subext(0))
(* integer passed_mfactor = "m"; *)
 R0_15 (net20[14], D, GSB);
rdp_io #(.l(5.1e-07), .w(4e-05), .m(1), .par1(1), .xf_subext(0))
(* integer passed_mfactor = "m"; *)
 R0_16 (net20[15], D, GSB);
rdp_io #(.l(5.1e-07), .w(4e-05), .m(1), .par1(1), .xf_subext(0))
(* integer passed_mfactor = "m"; *)
 R0_17 (net20[16], D, GSB);
rdp_io #(.l(5.1e-07), .w(4e-05), .m(1), .par1(1), .xf_subext(0))
(* integer passed_mfactor = "m"; *)
 R0_18 (net20[17], D, GSB);
rdp_io #(.l(5.1e-07), .w(4e-05), .m(1), .par1(1), .xf_subext(0))
(* integer passed_mfactor = "m"; *)
 R0_19 (net20[18], D, GSB);
rdp_io #(.l(5.1e-07), .w(4e-05), .m(1), .par1(1), .xf_subext(0))
(* integer passed_mfactor = "m"; *)
 R0_20 (net20[19], D, GSB);
rdp_io #(.l(5.1e-07), .w(4e-05), .m(1), .par1(1), .xf_subext(0))
(* integer passed_mfactor = "m"; *)
 R0_21 (net20[20], D, GSB);
rdp_io #(.l(5.1e-07), .w(4e-05), .m(1), .par1(1), .xf_subext(0))
(* integer passed_mfactor = "m"; *)
 R0_22 (net20[21], D, GSB);
rdp_io #(.l(5.1e-07), .w(4e-05), .m(1), .par1(1), .xf_subext(0))
(* integer passed_mfactor = "m"; *)
 R0_23 (net20[22], D, GSB);
rdp_io #(.l(5.1e-07), .w(4e-05), .m(1), .par1(1), .xf_subext(0))
(* integer passed_mfactor = "m"; *)
 R0_24 (net20[23], D, GSB);
rdp_io #(.l(5.1e-07), .w(4e-05), .m(1), .par1(1), .xf_subext(0))
(* integer passed_mfactor = "m"; *)
 R0_25 (net20[24], D, GSB);
rdp_io #(.l(5.1e-07), .w(4e-05), .m(1), .par1(1), .xf_subext(0))
(* integer passed_mfactor = "m"; *)
 R0_26 (net20[25], D, GSB);
rdp_io #(.l(5.1e-07), .w(4e-05), .m(1), .par1(1), .xf_subext(0))
(* integer passed_mfactor = "m"; *)
 R0_27 (net20[26], D, GSB);
rdp_io #(.l(5.1e-07), .w(4e-05), .m(1), .par1(1), .xf_subext(0))
(* integer passed_mfactor = "m"; *)
 R0_28 (net20[27], D, GSB);
rdp_io #(.l(5.1e-07), .w(4e-05), .m(1), .par1(1), .xf_subext(0))
(* integer passed_mfactor = "m"; *)
 R0_29 (net20[28], D, GSB);
rdp_io #(.l(5.1e-07), .w(4e-05), .m(1), .par1(1), .xf_subext(0))
(* integer passed_mfactor = "m"; *)
 R0_30 (net20[29], D, GSB);
rdp_io #(.l(5.1e-07), .w(4e-05), .m(1), .par1(1), .xf_subext(0))
(* integer passed_mfactor = "m"; *)
 R0_31 (net20[30], D, GSB);
rdp_io #(.l(5.1e-07), .w(4e-05), .m(1), .par1(1), .xf_subext(0))
(* integer passed_mfactor = "m"; *)
 R0_32 (net20[31], D, GSB);
rdp_io #(.l(5.1e-07), .w(4e-05), .m(1), .par1(1), .xf_subext(0))
(* integer passed_mfactor = "m"; *)
 R0_33 (net20[32], D, GSB);
rdp_io #(.l(5.1e-07), .w(4e-05), .m(1), .par1(1), .xf_subext(0))
(* integer passed_mfactor = "m"; *)
 R0_34 (net20[33], D, GSB);
rdp_io #(.l(5.1e-07), .w(4e-05), .m(1), .par1(1), .xf_subext(0))
(* integer passed_mfactor = "m"; *)
 R0_35 (net20[34], D, GSB);
rdp_io #(.l(5.1e-07), .w(4e-05), .m(1), .par1(1), .xf_subext(0))
(* integer passed_mfactor = "m"; *)
 R0_36 (net20[35], D, GSB);
rdp_io #(.l(5.1e-07), .w(4e-05), .m(1), .par1(1), .xf_subext(0))
(* integer passed_mfactor = "m"; *)
 R0_37 (net20[36], D, GSB);
rdp_io #(.l(5.1e-07), .w(4e-05), .m(1), .par1(1), .xf_subext(0))
(* integer passed_mfactor = "m"; *)
 R0_38 (net20[37], D, GSB);
rdp_io #(.l(5.1e-07), .w(4e-05), .m(1), .par1(1), .xf_subext(0))
(* integer passed_mfactor = "m"; *)
 R0_39 (net20[38], D, GSB);
rdp_io #(.l(5.1e-07), .w(4e-05), .m(1), .par1(1), .xf_subext(0))
(* integer passed_mfactor = "m"; *)
 R0_40 (net20[39], D, GSB);
rdp_io #(.l(5.1e-07), .w(4e-05), .m(1), .par1(1), .xf_subext(0))
(* integer passed_mfactor = "m"; *)
 R0_41 (net20[40], D, GSB);
rdp_io #(.l(5.1e-07), .w(4e-05), .m(1), .par1(1), .xf_subext(0))
(* integer passed_mfactor = "m"; *)
 R0_42 (net20[41], D, GSB);
rdp_io #(.l(5.1e-07), .w(4e-05), .m(1), .par1(1), .xf_subext(0))
(* integer passed_mfactor = "m"; *)
 R0_43 (net20[42], D, GSB);
rdp_io #(.l(5.1e-07), .w(4e-05), .m(1), .par1(1), .xf_subext(0))
(* integer passed_mfactor = "m"; *)
 R0_44 (net20[43], D, GSB);
rdp_io #(.l(5.1e-07), .w(4e-05), .m(1), .par1(1), .xf_subext(0))
(* integer passed_mfactor = "m"; *)
 R0_45 (net20[44], D, GSB);
rdp_io #(.l(5.1e-07), .w(4e-05), .m(1), .par1(1), .xf_subext(0))
(* integer passed_mfactor = "m"; *)
 R0_46 (net20[45], D, GSB);
rdp_io #(.l(5.1e-07), .w(4e-05), .m(1), .par1(1), .xf_subext(0))
(* integer passed_mfactor = "m"; *)
 R0_47 (net20[46], D, GSB);
rdp_io #(.l(5.1e-07), .w(4e-05), .m(1), .par1(1), .xf_subext(0))
(* integer passed_mfactor = "m"; *)
 R0_48 (net20[47], D, GSB);
rdp_io #(.l(5.1e-07), .w(4e-05), .m(1), .par1(1), .xf_subext(0))
(* integer passed_mfactor = "m"; *)
 R0_49 (net20[48], D, GSB);
rdp_io #(.l(5.1e-07), .w(4e-05), .m(1), .par1(1), .xf_subext(0))
(* integer passed_mfactor = "m"; *)
 R0_50 (net20[49], D, GSB);
dphnw #(.area(1.32132e-11), .perimeter(6.6e-07), .dbv(0), .m(1), .par1(1))
(* integer passed_mfactor = "m"; *)
 D0_1 (D, GSB);
dphnw #(.area(1.32132e-11), .perimeter(6.6e-07), .dbv(0), .m(1), .par1(1))
(* integer passed_mfactor = "m"; *)
 D0_2 (D, GSB);
dphnw #(.area(1.32132e-11), .perimeter(6.6e-07), .dbv(0), .m(1), .par1(1))
(* integer passed_mfactor = "m"; *)
 D0_3 (D, GSB);
dphnw #(.area(1.32132e-11), .perimeter(6.6e-07), .dbv(0), .m(1), .par1(1))
(* integer passed_mfactor = "m"; *)
 D0_4 (D, GSB);
dphnw #(.area(1.32132e-11), .perimeter(6.6e-07), .dbv(0), .m(1), .par1(1))
(* integer passed_mfactor = "m"; *)
 D0_5 (D, GSB);
dphnw #(.area(1.32132e-11), .perimeter(6.6e-07), .dbv(0), .m(1), .par1(1))
(* integer passed_mfactor = "m"; *)
 D0_6 (D, GSB);
dphnw #(.area(1.32132e-11), .perimeter(6.6e-07), .dbv(0), .m(1), .par1(1))
(* integer passed_mfactor = "m"; *)
 D0_7 (D, GSB);
dphnw #(.area(1.32132e-11), .perimeter(6.6e-07), .dbv(0), .m(1), .par1(1))
(* integer passed_mfactor = "m"; *)
 D0_8 (D, GSB);
dphnw #(.area(1.32132e-11), .perimeter(6.6e-07), .dbv(0), .m(1), .par1(1))
(* integer passed_mfactor = "m"; *)
 D0_9 (D, GSB);
dphnw #(.area(1.32132e-11), .perimeter(6.6e-07), .dbv(0), .m(1), .par1(1))
(* integer passed_mfactor = "m"; *)
 D0_10 (D, GSB);
dphnw #(.area(1.32132e-11), .perimeter(6.6e-07), .dbv(0), .m(1), .par1(1))
(* integer passed_mfactor = "m"; *)
 D0_11 (D, GSB);
dphnw #(.area(1.32132e-11), .perimeter(6.6e-07), .dbv(0), .m(1), .par1(1))
(* integer passed_mfactor = "m"; *)
 D0_12 (D, GSB);
dphnw #(.area(1.32132e-11), .perimeter(6.6e-07), .dbv(0), .m(1), .par1(1))
(* integer passed_mfactor = "m"; *)
 D0_13 (D, GSB);
dphnw #(.area(1.32132e-11), .perimeter(6.6e-07), .dbv(0), .m(1), .par1(1))
(* integer passed_mfactor = "m"; *)
 D0_14 (D, GSB);
dphnw #(.area(1.32132e-11), .perimeter(6.6e-07), .dbv(0), .m(1), .par1(1))
(* integer passed_mfactor = "m"; *)
 D0_15 (D, GSB);
dphnw #(.area(1.32132e-11), .perimeter(6.6e-07), .dbv(0), .m(1), .par1(1))
(* integer passed_mfactor = "m"; *)
 D0_16 (D, GSB);
dphnw #(.area(1.32132e-11), .perimeter(6.6e-07), .dbv(0), .m(1), .par1(1))
(* integer passed_mfactor = "m"; *)
 D0_17 (D, GSB);
dphnw #(.area(1.32132e-11), .perimeter(6.6e-07), .dbv(0), .m(1), .par1(1))
(* integer passed_mfactor = "m"; *)
 D0_18 (D, GSB);
dphnw #(.area(1.32132e-11), .perimeter(6.6e-07), .dbv(0), .m(1), .par1(1))
(* integer passed_mfactor = "m"; *)
 D0_19 (D, GSB);
dphnw #(.area(1.32132e-11), .perimeter(6.6e-07), .dbv(0), .m(1), .par1(1))
(* integer passed_mfactor = "m"; *)
 D0_20 (D, GSB);
dphnw #(.area(1.32132e-11), .perimeter(6.6e-07), .dbv(0), .m(1), .par1(1))
(* integer passed_mfactor = "m"; *)
 D0_21 (D, GSB);
dphnw #(.area(1.32132e-11), .perimeter(6.6e-07), .dbv(0), .m(1), .par1(1))
(* integer passed_mfactor = "m"; *)
 D0_22 (D, GSB);
dphnw #(.area(1.32132e-11), .perimeter(6.6e-07), .dbv(0), .m(1), .par1(1))
(* integer passed_mfactor = "m"; *)
 D0_23 (D, GSB);
dphnw #(.area(1.32132e-11), .perimeter(6.6e-07), .dbv(0), .m(1), .par1(1))
(* integer passed_mfactor = "m"; *)
 D0_24 (D, GSB);
dphnw #(.area(1.32132e-11), .perimeter(6.6e-07), .dbv(0), .m(1), .par1(1))
(* integer passed_mfactor = "m"; *)
 D0_25 (D, GSB);
dphnw #(.area(1.32132e-11), .perimeter(6.6e-07), .dbv(0), .m(1), .par1(1))
(* integer passed_mfactor = "m"; *)
 D0_26 (D, GSB);
dphnw #(.area(1.32132e-11), .perimeter(6.6e-07), .dbv(0), .m(1), .par1(1))
(* integer passed_mfactor = "m"; *)
 D0_27 (D, GSB);
dphnw #(.area(1.32132e-11), .perimeter(6.6e-07), .dbv(0), .m(1), .par1(1))
(* integer passed_mfactor = "m"; *)
 D0_28 (D, GSB);
dphnw #(.area(1.32132e-11), .perimeter(6.6e-07), .dbv(0), .m(1), .par1(1))
(* integer passed_mfactor = "m"; *)
 D0_29 (D, GSB);
dphnw #(.area(1.32132e-11), .perimeter(6.6e-07), .dbv(0), .m(1), .par1(1))
(* integer passed_mfactor = "m"; *)
 D0_30 (D, GSB);
dphnw #(.area(1.32132e-11), .perimeter(6.6e-07), .dbv(0), .m(1), .par1(1))
(* integer passed_mfactor = "m"; *)
 D0_31 (D, GSB);
dphnw #(.area(1.32132e-11), .perimeter(6.6e-07), .dbv(0), .m(1), .par1(1))
(* integer passed_mfactor = "m"; *)
 D0_32 (D, GSB);
dphnw #(.area(1.32132e-11), .perimeter(6.6e-07), .dbv(0), .m(1), .par1(1))
(* integer passed_mfactor = "m"; *)
 D0_33 (D, GSB);
dphnw #(.area(1.32132e-11), .perimeter(6.6e-07), .dbv(0), .m(1), .par1(1))
(* integer passed_mfactor = "m"; *)
 D0_34 (D, GSB);
dphnw #(.area(1.32132e-11), .perimeter(6.6e-07), .dbv(0), .m(1), .par1(1))
(* integer passed_mfactor = "m"; *)
 D0_35 (D, GSB);
dphnw #(.area(1.32132e-11), .perimeter(6.6e-07), .dbv(0), .m(1), .par1(1))
(* integer passed_mfactor = "m"; *)
 D0_36 (D, GSB);
dphnw #(.area(1.32132e-11), .perimeter(6.6e-07), .dbv(0), .m(1), .par1(1))
(* integer passed_mfactor = "m"; *)
 D0_37 (D, GSB);
dphnw #(.area(1.32132e-11), .perimeter(6.6e-07), .dbv(0), .m(1), .par1(1))
(* integer passed_mfactor = "m"; *)
 D0_38 (D, GSB);
dphnw #(.area(1.32132e-11), .perimeter(6.6e-07), .dbv(0), .m(1), .par1(1))
(* integer passed_mfactor = "m"; *)
 D0_39 (D, GSB);
dphnw #(.area(1.32132e-11), .perimeter(6.6e-07), .dbv(0), .m(1), .par1(1))
(* integer passed_mfactor = "m"; *)
 D0_40 (D, GSB);
dphnw #(.area(1.32132e-11), .perimeter(6.6e-07), .dbv(0), .m(1), .par1(1))
(* integer passed_mfactor = "m"; *)
 D0_41 (D, GSB);
dphnw #(.area(1.32132e-11), .perimeter(6.6e-07), .dbv(0), .m(1), .par1(1))
(* integer passed_mfactor = "m"; *)
 D0_42 (D, GSB);
dphnw #(.area(1.32132e-11), .perimeter(6.6e-07), .dbv(0), .m(1), .par1(1))
(* integer passed_mfactor = "m"; *)
 D0_43 (D, GSB);
dphnw #(.area(1.32132e-11), .perimeter(6.6e-07), .dbv(0), .m(1), .par1(1))
(* integer passed_mfactor = "m"; *)
 D0_44 (D, GSB);
dphnw #(.area(1.32132e-11), .perimeter(6.6e-07), .dbv(0), .m(1), .par1(1))
(* integer passed_mfactor = "m"; *)
 D0_45 (D, GSB);
dphnw #(.area(1.32132e-11), .perimeter(6.6e-07), .dbv(0), .m(1), .par1(1))
(* integer passed_mfactor = "m"; *)
 D0_46 (D, GSB);
dphnw #(.area(1.32132e-11), .perimeter(6.6e-07), .dbv(0), .m(1), .par1(1))
(* integer passed_mfactor = "m"; *)
 D0_47 (D, GSB);
dphnw #(.area(1.32132e-11), .perimeter(6.6e-07), .dbv(0), .m(1), .par1(1))
(* integer passed_mfactor = "m"; *)
 D0_48 (D, GSB);
dphnw #(.area(1.32132e-11), .perimeter(6.6e-07), .dbv(0), .m(1), .par1(1))
(* integer passed_mfactor = "m"; *)
 D0_49 (D, GSB);
dphnw #(.area(1.32132e-11), .perimeter(6.6e-07), .dbv(0), .m(1), .par1(1))
(* integer passed_mfactor = "m"; *)
 D0_50 (D, GSB);
ddnw #(.area(5.93593e-09), .perimeter(0.0003342), .dbv(0), .m(1), .par1(1), .xf_subext(0))
(* integer passed_mfactor = "m"; *)
 D1 (Sub, GSB);

endmodule
// Library - HV_CELLS, Cell - ioh_pe3isab_40_04, View - schematic
// LAST TIME SAVED: Feb 25 05:55:55 2015
// NETLIST TIME: Feb  9 05:16:35 2024

`worklib HV_CELLS
`view schematic

`timescale 1ns / 1ps
(* cds_ams_schematic *)

module ioh_pe3isab_40_04 (B, D, G, S);
inout  B, D, G, S;
pe3i #(.w(4e-05), .l(4e-07), .as(1.92e-11), .ad(1.92e-11), .ps(8.096e-05), .pd(8.096e-05), .nrs(0.00675), .nrd(0.00675), .m((1)*(1)), .par1((1)*(1)))
(* integer passed_mfactor = "m"; *)
 MPX (net17, G, S, B);
rdp3 #(.l(4.3e-07), .w(4e-05), .m(1), .par1(1))
(* integer passed_mfactor = "m"; *)
 R0 (net17, D, B);

endmodule
// Library - HV_CELLS, Cell - ioh_pe3isabhv_2800gcr, View - schematic
// LAST TIME SAVED: Feb 25 05:55:56 2015
// NETLIST TIME: Feb  9 05:16:35 2024

`worklib HV_CELLS
`view schematic

`timescale 1ns / 1ps
(* cds_ams_schematic *)

module ioh_pe3isabhv_2800gcr (D, SB, Sub);
inout  D, SB, Sub;
wire net20;
ioh_pe3isab_40_04 MP_1 (.D( D ), .B( SB ), .G( net20 ), .S( SB ));
ioh_pe3isab_40_04 MP_2 (.D( D ), .B( SB ), .G( net20 ), .S( SB ));
ioh_pe3isab_40_04 MP_3 (.D( D ), .B( SB ), .G( net20 ), .S( SB ));
ioh_pe3isab_40_04 MP_4 (.D( D ), .B( SB ), .G( net20 ), .S( SB ));
ioh_pe3isab_40_04 MP_5 (.D( D ), .B( SB ), .G( net20 ), .S( SB ));
ioh_pe3isab_40_04 MP_6 (.D( D ), .B( SB ), .G( net20 ), .S( SB ));
ioh_pe3isab_40_04 MP_7 (.D( D ), .B( SB ), .G( net20 ), .S( SB ));
ioh_pe3isab_40_04 MP_8 (.D( D ), .B( SB ), .G( net20 ), .S( SB ));
ioh_pe3isab_40_04 MP_9 (.D( D ), .B( SB ), .G( net20 ), .S( SB ));
ioh_pe3isab_40_04 MP_10 (.D( D ), .B( SB ), .G( net20 ), .S( SB ));
ioh_pe3isab_40_04 MP_11 (.D( D ), .B( SB ), .G( net20 ), .S( SB ));
ioh_pe3isab_40_04 MP_12 (.D( D ), .B( SB ), .G( net20 ), .S( SB ));
ioh_pe3isab_40_04 MP_13 (.D( D ), .B( SB ), .G( net20 ), .S( SB ));
ioh_pe3isab_40_04 MP_14 (.D( D ), .B( SB ), .G( net20 ), .S( SB ));
ioh_pe3isab_40_04 MP_15 (.D( D ), .B( SB ), .G( net20 ), .S( SB ));
ioh_pe3isab_40_04 MP_16 (.D( D ), .B( SB ), .G( net20 ), .S( SB ));
ioh_pe3isab_40_04 MP_17 (.D( D ), .B( SB ), .G( net20 ), .S( SB ));
ioh_pe3isab_40_04 MP_18 (.D( D ), .B( SB ), .G( net20 ), .S( SB ));
ioh_pe3isab_40_04 MP_19 (.D( D ), .B( SB ), .G( net20 ), .S( SB ));
ioh_pe3isab_40_04 MP_20 (.D( D ), .B( SB ), .G( net20 ), .S( SB ));
ioh_pe3isab_40_04 MP_21 (.D( D ), .B( SB ), .G( net20 ), .S( SB ));
ioh_pe3isab_40_04 MP_22 (.D( D ), .B( SB ), .G( net20 ), .S( SB ));
ioh_pe3isab_40_04 MP_23 (.D( D ), .B( SB ), .G( net20 ), .S( SB ));
ioh_pe3isab_40_04 MP_24 (.D( D ), .B( SB ), .G( net20 ), .S( SB ));
ioh_pe3isab_40_04 MP_25 (.D( D ), .B( SB ), .G( net20 ), .S( SB ));
ioh_pe3isab_40_04 MP_26 (.D( D ), .B( SB ), .G( net20 ), .S( SB ));
ioh_pe3isab_40_04 MP_27 (.D( D ), .B( SB ), .G( net20 ), .S( SB ));
ioh_pe3isab_40_04 MP_28 (.D( D ), .B( SB ), .G( net20 ), .S( SB ));
ioh_pe3isab_40_04 MP_29 (.D( D ), .B( SB ), .G( net20 ), .S( SB ));
ioh_pe3isab_40_04 MP_30 (.D( D ), .B( SB ), .G( net20 ), .S( SB ));
ioh_pe3isab_40_04 MP_31 (.D( D ), .B( SB ), .G( net20 ), .S( SB ));
ioh_pe3isab_40_04 MP_32 (.D( D ), .B( SB ), .G( net20 ), .S( SB ));
ioh_pe3isab_40_04 MP_33 (.D( D ), .B( SB ), .G( net20 ), .S( SB ));
ioh_pe3isab_40_04 MP_34 (.D( D ), .B( SB ), .G( net20 ), .S( SB ));
ioh_pe3isab_40_04 MP_35 (.D( D ), .B( SB ), .G( net20 ), .S( SB ));
ioh_pe3isab_40_04 MP_36 (.D( D ), .B( SB ), .G( net20 ), .S( SB ));
ioh_pe3isab_40_04 MP_37 (.D( D ), .B( SB ), .G( net20 ), .S( SB ));
ioh_pe3isab_40_04 MP_38 (.D( D ), .B( SB ), .G( net20 ), .S( SB ));
ioh_pe3isab_40_04 MP_39 (.D( D ), .B( SB ), .G( net20 ), .S( SB ));
ioh_pe3isab_40_04 MP_40 (.D( D ), .B( SB ), .G( net20 ), .S( SB ));
ioh_pe3isab_40_04 MP_41 (.D( D ), .B( SB ), .G( net20 ), .S( SB ));
ioh_pe3isab_40_04 MP_42 (.D( D ), .B( SB ), .G( net20 ), .S( SB ));
ioh_pe3isab_40_04 MP_43 (.D( D ), .B( SB ), .G( net20 ), .S( SB ));
ioh_pe3isab_40_04 MP_44 (.D( D ), .B( SB ), .G( net20 ), .S( SB ));
ioh_pe3isab_40_04 MP_45 (.D( D ), .B( SB ), .G( net20 ), .S( SB ));
ioh_pe3isab_40_04 MP_46 (.D( D ), .B( SB ), .G( net20 ), .S( SB ));
ioh_pe3isab_40_04 MP_47 (.D( D ), .B( SB ), .G( net20 ), .S( SB ));
ioh_pe3isab_40_04 MP_48 (.D( D ), .B( SB ), .G( net20 ), .S( SB ));
ioh_pe3isab_40_04 MP_49 (.D( D ), .B( SB ), .G( net20 ), .S( SB ));
ioh_pe3isab_40_04 MP_50 (.D( D ), .B( SB ), .G( net20 ), .S( SB ));
ioh_pe3isab_40_04 MP_51 (.D( D ), .B( SB ), .G( net20 ), .S( SB ));
ioh_pe3isab_40_04 MP_52 (.D( D ), .B( SB ), .G( net20 ), .S( SB ));
ioh_pe3isab_40_04 MP_53 (.D( D ), .B( SB ), .G( net20 ), .S( SB ));
ioh_pe3isab_40_04 MP_54 (.D( D ), .B( SB ), .G( net20 ), .S( SB ));
ioh_pe3isab_40_04 MP_55 (.D( D ), .B( SB ), .G( net20 ), .S( SB ));
ioh_pe3isab_40_04 MP_56 (.D( D ), .B( SB ), .G( net20 ), .S( SB ));
ioh_pe3isab_40_04 MP_57 (.D( D ), .B( SB ), .G( net20 ), .S( SB ));
ioh_pe3isab_40_04 MP_58 (.D( D ), .B( SB ), .G( net20 ), .S( SB ));
ioh_pe3isab_40_04 MP_59 (.D( D ), .B( SB ), .G( net20 ), .S( SB ));
ioh_pe3isab_40_04 MP_60 (.D( D ), .B( SB ), .G( net20 ), .S( SB ));
ioh_pe3isab_40_04 MP_61 (.D( D ), .B( SB ), .G( net20 ), .S( SB ));
ioh_pe3isab_40_04 MP_62 (.D( D ), .B( SB ), .G( net20 ), .S( SB ));
ioh_pe3isab_40_04 MP_63 (.D( D ), .B( SB ), .G( net20 ), .S( SB ));
ioh_pe3isab_40_04 MP_64 (.D( D ), .B( SB ), .G( net20 ), .S( SB ));
ioh_pe3isab_40_04 MP_65 (.D( D ), .B( SB ), .G( net20 ), .S( SB ));
ioh_pe3isab_40_04 MP_66 (.D( D ), .B( SB ), .G( net20 ), .S( SB ));
ioh_pe3isab_40_04 MP_67 (.D( D ), .B( SB ), .G( net20 ), .S( SB ));
ioh_pe3isab_40_04 MP_68 (.D( D ), .B( SB ), .G( net20 ), .S( SB ));
ioh_pe3isab_40_04 MP_69 (.D( D ), .B( SB ), .G( net20 ), .S( SB ));
ioh_pe3isab_40_04 MP_70 (.D( D ), .B( SB ), .G( net20 ), .S( SB ));
dp3 #(.area(2.64196e-11), .perimeter(1.32e-06), .dbv(0), .m(1), .par1(1))
(* integer passed_mfactor = "m"; *)
 MD_1 (D, SB);
dp3 #(.area(2.64196e-11), .perimeter(1.32e-06), .dbv(0), .m(1), .par1(1))
(* integer passed_mfactor = "m"; *)
 MD_2 (D, SB);
dp3 #(.area(2.64196e-11), .perimeter(1.32e-06), .dbv(0), .m(1), .par1(1))
(* integer passed_mfactor = "m"; *)
 MD_3 (D, SB);
dp3 #(.area(2.64196e-11), .perimeter(1.32e-06), .dbv(0), .m(1), .par1(1))
(* integer passed_mfactor = "m"; *)
 MD_4 (D, SB);
dp3 #(.area(2.64196e-11), .perimeter(1.32e-06), .dbv(0), .m(1), .par1(1))
(* integer passed_mfactor = "m"; *)
 MD_5 (D, SB);
dp3 #(.area(2.64196e-11), .perimeter(1.32e-06), .dbv(0), .m(1), .par1(1))
(* integer passed_mfactor = "m"; *)
 MD_6 (D, SB);
dp3 #(.area(2.64196e-11), .perimeter(1.32e-06), .dbv(0), .m(1), .par1(1))
(* integer passed_mfactor = "m"; *)
 MD_7 (D, SB);
dp3 #(.area(2.64196e-11), .perimeter(1.32e-06), .dbv(0), .m(1), .par1(1))
(* integer passed_mfactor = "m"; *)
 MD_8 (D, SB);
dp3 #(.area(2.64196e-11), .perimeter(1.32e-06), .dbv(0), .m(1), .par1(1))
(* integer passed_mfactor = "m"; *)
 MD_9 (D, SB);
dp3 #(.area(2.64196e-11), .perimeter(1.32e-06), .dbv(0), .m(1), .par1(1))
(* integer passed_mfactor = "m"; *)
 MD_10 (D, SB);
dp3 #(.area(2.64196e-11), .perimeter(1.32e-06), .dbv(0), .m(1), .par1(1))
(* integer passed_mfactor = "m"; *)
 MD_11 (D, SB);
dp3 #(.area(2.64196e-11), .perimeter(1.32e-06), .dbv(0), .m(1), .par1(1))
(* integer passed_mfactor = "m"; *)
 MD_12 (D, SB);
dp3 #(.area(2.64196e-11), .perimeter(1.32e-06), .dbv(0), .m(1), .par1(1))
(* integer passed_mfactor = "m"; *)
 MD_13 (D, SB);
dp3 #(.area(2.64196e-11), .perimeter(1.32e-06), .dbv(0), .m(1), .par1(1))
(* integer passed_mfactor = "m"; *)
 MD_14 (D, SB);
dp3 #(.area(2.64196e-11), .perimeter(1.32e-06), .dbv(0), .m(1), .par1(1))
(* integer passed_mfactor = "m"; *)
 MD_15 (D, SB);
dp3 #(.area(2.64196e-11), .perimeter(1.32e-06), .dbv(0), .m(1), .par1(1))
(* integer passed_mfactor = "m"; *)
 MD_16 (D, SB);
dp3 #(.area(2.64196e-11), .perimeter(1.32e-06), .dbv(0), .m(1), .par1(1))
(* integer passed_mfactor = "m"; *)
 MD_17 (D, SB);
dp3 #(.area(2.64196e-11), .perimeter(1.32e-06), .dbv(0), .m(1), .par1(1))
(* integer passed_mfactor = "m"; *)
 MD_18 (D, SB);
dp3 #(.area(2.64196e-11), .perimeter(1.32e-06), .dbv(0), .m(1), .par1(1))
(* integer passed_mfactor = "m"; *)
 MD_19 (D, SB);
dp3 #(.area(2.64196e-11), .perimeter(1.32e-06), .dbv(0), .m(1), .par1(1))
(* integer passed_mfactor = "m"; *)
 MD_20 (D, SB);
dp3 #(.area(2.64196e-11), .perimeter(1.32e-06), .dbv(0), .m(1), .par1(1))
(* integer passed_mfactor = "m"; *)
 MD_21 (D, SB);
dp3 #(.area(2.64196e-11), .perimeter(1.32e-06), .dbv(0), .m(1), .par1(1))
(* integer passed_mfactor = "m"; *)
 MD_22 (D, SB);
dp3 #(.area(2.64196e-11), .perimeter(1.32e-06), .dbv(0), .m(1), .par1(1))
(* integer passed_mfactor = "m"; *)
 MD_23 (D, SB);
dp3 #(.area(2.64196e-11), .perimeter(1.32e-06), .dbv(0), .m(1), .par1(1))
(* integer passed_mfactor = "m"; *)
 MD_24 (D, SB);
dp3 #(.area(2.64196e-11), .perimeter(1.32e-06), .dbv(0), .m(1), .par1(1))
(* integer passed_mfactor = "m"; *)
 MD_25 (D, SB);
dp3 #(.area(2.64196e-11), .perimeter(1.32e-06), .dbv(0), .m(1), .par1(1))
(* integer passed_mfactor = "m"; *)
 MD_26 (D, SB);
dp3 #(.area(2.64196e-11), .perimeter(1.32e-06), .dbv(0), .m(1), .par1(1))
(* integer passed_mfactor = "m"; *)
 MD_27 (D, SB);
dp3 #(.area(2.64196e-11), .perimeter(1.32e-06), .dbv(0), .m(1), .par1(1))
(* integer passed_mfactor = "m"; *)
 MD_28 (D, SB);
dp3 #(.area(2.64196e-11), .perimeter(1.32e-06), .dbv(0), .m(1), .par1(1))
(* integer passed_mfactor = "m"; *)
 MD_29 (D, SB);
dp3 #(.area(2.64196e-11), .perimeter(1.32e-06), .dbv(0), .m(1), .par1(1))
(* integer passed_mfactor = "m"; *)
 MD_30 (D, SB);
dp3 #(.area(2.64196e-11), .perimeter(1.32e-06), .dbv(0), .m(1), .par1(1))
(* integer passed_mfactor = "m"; *)
 MD_31 (D, SB);
dp3 #(.area(2.64196e-11), .perimeter(1.32e-06), .dbv(0), .m(1), .par1(1))
(* integer passed_mfactor = "m"; *)
 MD_32 (D, SB);
dp3 #(.area(2.64196e-11), .perimeter(1.32e-06), .dbv(0), .m(1), .par1(1))
(* integer passed_mfactor = "m"; *)
 MD_33 (D, SB);
dp3 #(.area(2.64196e-11), .perimeter(1.32e-06), .dbv(0), .m(1), .par1(1))
(* integer passed_mfactor = "m"; *)
 MD_34 (D, SB);
dp3 #(.area(2.64196e-11), .perimeter(1.32e-06), .dbv(0), .m(1), .par1(1))
(* integer passed_mfactor = "m"; *)
 MD_35 (D, SB);
ddnw #(.area(5.99695e-09), .perimeter(0.0003352), .dbv(0), .m(1), .par1(1), .xf_subext(0))
(* integer passed_mfactor = "m"; *)
 D0 (Sub, SB);
rnp1 #(.l(2.55e-05), .w(4.2e-07), .m(1), .par1(1))
(* integer passed_mfactor = "m"; *)
 R0 (SB, net20);

endmodule
// Library - HV_CELLS, Cell - ioh_d5pk, View - schematic
// LAST TIME SAVED: Feb 25 05:55:49 2015
// NETLIST TIME: Feb  9 05:16:35 2024

`worklib HV_CELLS
`view schematic

`timescale 1ns / 1ps
(* cds_ams_schematic *)

module ioh_d5pk (A_l, K_h, Sub);
inout  A_l, K_h, Sub;
wire net29;
wire net26;
wire net18;
wire net23;
ioh_pmbsabhv_2000 I3 (.Sub( Sub ), .D( net26 ), .GSB( net29 ));
ioh_pmbsabhv_2000 I4 (.Sub( Sub ), .D( net18 ), .GSB( net26 ));
ioh_pmbsabhv_2000 I2 (.Sub( Sub ), .D( net29 ), .GSB( net23 ));
ioh_pmbsabhv_2000 I1 (.Sub( Sub ), .D( net23 ), .GSB( K_h ));
ioh_pe3isabhv_2800gcr I5 (.Sub( Sub ), .SB( net18 ), .D( A_l ));

endmodule
// Library - HV_CELLS, Cell - HVDD4DJ5PKFs, View - schematic
// LAST TIME SAVED: Feb 25 05:55:38 2015
// NETLIST TIME: Feb  9 05:16:35 2024

`worklib HV_CELLS
`view schematic

`timescale 1ns / 1ps
(* cds_ams_schematic *)

module HVDD4DJ5PKFs (GNDO, IGND, PAD);
inout  GNDO, IGND, PAD;
ioh_dhpw_2x100_stack3 I9 (.A_l( IGND ), .Sub( GNDO ), .K_h( PAD ));
ioh_d5pk I11 (.Sub( GNDO ), .K_h( PAD ), .A_l( IGND ));

endmodule
// Library - HV_CELLS, Cell - ioh_d2pk, View - schematic
// LAST TIME SAVED: Feb 25 05:55:50 2015
// NETLIST TIME: Feb  9 05:16:35 2024

`worklib HV_CELLS
`view schematic

`timescale 1ns / 1ps
(* cds_ams_schematic *)

module ioh_d2pk (A_l, K_h, Sub);
inout  A_l, K_h, Sub;
wire net12;
ioh_pmbsabhv_2000 I1 (.GSB( K_h ), .Sub( Sub ), .D( net12 ));
ioh_pe3isabhv_2800gcr I5 (.Sub( Sub ), .SB( net12 ), .D( A_l ));

endmodule
// Library - HV_CELLS, Cell - HVDD4D2PK, View - schematic
// LAST TIME SAVED: Feb 25 05:55:34 2015
// NETLIST TIME: Feb  9 05:16:35 2024

`worklib HV_CELLS
`view schematic

`timescale 1ns / 1ps
(* cds_ams_schematic *)

module HVDD4D2PK (GND, PAD);
inout  GND, PAD;
ioh_d2pk I11 (.Sub( GND ), .K_h( PAD ), .A_l( GND ));
ddnw #(.area(3.89668e-10), .perimeter(0.0002085), .dbv(0), .m(1), .par1(1), .xf_subext(0))
(* integer passed_mfactor = "m"; *)
 D0 (GND, PAD);

endmodule
// Library - HV_CELLS, Cell - ioh_iscrd2_4x100, View - schematic
// LAST TIME SAVED: Feb 25 05:55:54 2015
// NETLIST TIME: Feb  9 05:16:35 2024

`worklib HV_CELLS
`view schematic

`timescale 1ns / 1ps
(* cds_ams_schematic *)

module ioh_iscrd2_4x100 (A, Gn, Gp, K, Sub);
inout  A, Gn, Gp, K, Sub;
dnpdd_scr #(.area(5.36386e-10), .perimeter(0.00040956), .dbv(0), .m(1))
(* integer passed_mfactor = "m"; *)
 D1 (Gp, K);
dpdd_scr #(.area(2.19633e-09), .perimeter(0.00045716), .dbv(0), .m(1))
(* integer passed_mfactor = "m"; *)
 D2 (Gp, Gn);
dpdnw #(.area(1.89063e-10), .perimeter(0.00020378), .dbv(0), .m(4), .par1(4))
(* integer passed_mfactor = "m"; *)
 D0 (A, Gn);
ddnw #(.area(6.92224e-09), .perimeter(0.00035917), .dbv(0), .m(1), .par1(1), .xf_subext(0))
(* integer passed_mfactor = "m"; *)
 D_Guard (Sub, Gn);

endmodule
// Library - HV_CELLS, Cell - ioh_pe3isab_15_04, View - schematic
// LAST TIME SAVED: Feb 25 05:55:55 2015
// NETLIST TIME: Feb  9 05:16:35 2024

`worklib HV_CELLS
`view schematic

`timescale 1ns / 1ps
(* cds_ams_schematic *)

module ioh_pe3isab_15_04 (B, D, G, S);
inout  B, D, G, S;
pe3i #(.w(1.5e-05), .l(4e-07), .as(7.2e-12), .ad(7.2e-12), .ps(3.096e-05), .pd(3.096e-05), .nrs(0.018), .nrd(0.018), .m((1)*(1)), .par1((1)*(1)))
(* integer passed_mfactor = "m"; *)
 MPX (net17, G, S, B);
rdp3 #(.l(4.3e-07), .w(1.5e-05), .m(1), .par1(1))
(* integer passed_mfactor = "m"; *)
 R0 (net17, D, B);

endmodule
// Library - HV_CELLS, Cell - ioh_pe3isabhv_1050gcr, View - schematic
// LAST TIME SAVED: Feb 25 05:55:55 2015
// NETLIST TIME: Feb  9 05:16:35 2024

`worklib HV_CELLS
`view schematic

`timescale 1ns / 1ps
(* cds_ams_schematic *)

module ioh_pe3isabhv_1050gcr (D, SB, Sub);
inout  D, SB, Sub;
wire net20;
ioh_pe3isab_15_04 MP_1 (.D( D ), .B( SB ), .G( net20 ), .S( SB ));
ioh_pe3isab_15_04 MP_2 (.D( D ), .B( SB ), .G( net20 ), .S( SB ));
ioh_pe3isab_15_04 MP_3 (.D( D ), .B( SB ), .G( net20 ), .S( SB ));
ioh_pe3isab_15_04 MP_4 (.D( D ), .B( SB ), .G( net20 ), .S( SB ));
ioh_pe3isab_15_04 MP_5 (.D( D ), .B( SB ), .G( net20 ), .S( SB ));
ioh_pe3isab_15_04 MP_6 (.D( D ), .B( SB ), .G( net20 ), .S( SB ));
ioh_pe3isab_15_04 MP_7 (.D( D ), .B( SB ), .G( net20 ), .S( SB ));
ioh_pe3isab_15_04 MP_8 (.D( D ), .B( SB ), .G( net20 ), .S( SB ));
ioh_pe3isab_15_04 MP_9 (.D( D ), .B( SB ), .G( net20 ), .S( SB ));
ioh_pe3isab_15_04 MP_10 (.D( D ), .B( SB ), .G( net20 ), .S( SB ));
ioh_pe3isab_15_04 MP_11 (.D( D ), .B( SB ), .G( net20 ), .S( SB ));
ioh_pe3isab_15_04 MP_12 (.D( D ), .B( SB ), .G( net20 ), .S( SB ));
ioh_pe3isab_15_04 MP_13 (.D( D ), .B( SB ), .G( net20 ), .S( SB ));
ioh_pe3isab_15_04 MP_14 (.D( D ), .B( SB ), .G( net20 ), .S( SB ));
ioh_pe3isab_15_04 MP_15 (.D( D ), .B( SB ), .G( net20 ), .S( SB ));
ioh_pe3isab_15_04 MP_16 (.D( D ), .B( SB ), .G( net20 ), .S( SB ));
ioh_pe3isab_15_04 MP_17 (.D( D ), .B( SB ), .G( net20 ), .S( SB ));
ioh_pe3isab_15_04 MP_18 (.D( D ), .B( SB ), .G( net20 ), .S( SB ));
ioh_pe3isab_15_04 MP_19 (.D( D ), .B( SB ), .G( net20 ), .S( SB ));
ioh_pe3isab_15_04 MP_20 (.D( D ), .B( SB ), .G( net20 ), .S( SB ));
ioh_pe3isab_15_04 MP_21 (.D( D ), .B( SB ), .G( net20 ), .S( SB ));
ioh_pe3isab_15_04 MP_22 (.D( D ), .B( SB ), .G( net20 ), .S( SB ));
ioh_pe3isab_15_04 MP_23 (.D( D ), .B( SB ), .G( net20 ), .S( SB ));
ioh_pe3isab_15_04 MP_24 (.D( D ), .B( SB ), .G( net20 ), .S( SB ));
ioh_pe3isab_15_04 MP_25 (.D( D ), .B( SB ), .G( net20 ), .S( SB ));
ioh_pe3isab_15_04 MP_26 (.D( D ), .B( SB ), .G( net20 ), .S( SB ));
ioh_pe3isab_15_04 MP_27 (.D( D ), .B( SB ), .G( net20 ), .S( SB ));
ioh_pe3isab_15_04 MP_28 (.D( D ), .B( SB ), .G( net20 ), .S( SB ));
ioh_pe3isab_15_04 MP_29 (.D( D ), .B( SB ), .G( net20 ), .S( SB ));
ioh_pe3isab_15_04 MP_30 (.D( D ), .B( SB ), .G( net20 ), .S( SB ));
ioh_pe3isab_15_04 MP_31 (.D( D ), .B( SB ), .G( net20 ), .S( SB ));
ioh_pe3isab_15_04 MP_32 (.D( D ), .B( SB ), .G( net20 ), .S( SB ));
ioh_pe3isab_15_04 MP_33 (.D( D ), .B( SB ), .G( net20 ), .S( SB ));
ioh_pe3isab_15_04 MP_34 (.D( D ), .B( SB ), .G( net20 ), .S( SB ));
ioh_pe3isab_15_04 MP_35 (.D( D ), .B( SB ), .G( net20 ), .S( SB ));
ioh_pe3isab_15_04 MP_36 (.D( D ), .B( SB ), .G( net20 ), .S( SB ));
ioh_pe3isab_15_04 MP_37 (.D( D ), .B( SB ), .G( net20 ), .S( SB ));
ioh_pe3isab_15_04 MP_38 (.D( D ), .B( SB ), .G( net20 ), .S( SB ));
ioh_pe3isab_15_04 MP_39 (.D( D ), .B( SB ), .G( net20 ), .S( SB ));
ioh_pe3isab_15_04 MP_40 (.D( D ), .B( SB ), .G( net20 ), .S( SB ));
ioh_pe3isab_15_04 MP_41 (.D( D ), .B( SB ), .G( net20 ), .S( SB ));
ioh_pe3isab_15_04 MP_42 (.D( D ), .B( SB ), .G( net20 ), .S( SB ));
ioh_pe3isab_15_04 MP_43 (.D( D ), .B( SB ), .G( net20 ), .S( SB ));
ioh_pe3isab_15_04 MP_44 (.D( D ), .B( SB ), .G( net20 ), .S( SB ));
ioh_pe3isab_15_04 MP_45 (.D( D ), .B( SB ), .G( net20 ), .S( SB ));
ioh_pe3isab_15_04 MP_46 (.D( D ), .B( SB ), .G( net20 ), .S( SB ));
ioh_pe3isab_15_04 MP_47 (.D( D ), .B( SB ), .G( net20 ), .S( SB ));
ioh_pe3isab_15_04 MP_48 (.D( D ), .B( SB ), .G( net20 ), .S( SB ));
ioh_pe3isab_15_04 MP_49 (.D( D ), .B( SB ), .G( net20 ), .S( SB ));
ioh_pe3isab_15_04 MP_50 (.D( D ), .B( SB ), .G( net20 ), .S( SB ));
ioh_pe3isab_15_04 MP_51 (.D( D ), .B( SB ), .G( net20 ), .S( SB ));
ioh_pe3isab_15_04 MP_52 (.D( D ), .B( SB ), .G( net20 ), .S( SB ));
ioh_pe3isab_15_04 MP_53 (.D( D ), .B( SB ), .G( net20 ), .S( SB ));
ioh_pe3isab_15_04 MP_54 (.D( D ), .B( SB ), .G( net20 ), .S( SB ));
ioh_pe3isab_15_04 MP_55 (.D( D ), .B( SB ), .G( net20 ), .S( SB ));
ioh_pe3isab_15_04 MP_56 (.D( D ), .B( SB ), .G( net20 ), .S( SB ));
ioh_pe3isab_15_04 MP_57 (.D( D ), .B( SB ), .G( net20 ), .S( SB ));
ioh_pe3isab_15_04 MP_58 (.D( D ), .B( SB ), .G( net20 ), .S( SB ));
ioh_pe3isab_15_04 MP_59 (.D( D ), .B( SB ), .G( net20 ), .S( SB ));
ioh_pe3isab_15_04 MP_60 (.D( D ), .B( SB ), .G( net20 ), .S( SB ));
ioh_pe3isab_15_04 MP_61 (.D( D ), .B( SB ), .G( net20 ), .S( SB ));
ioh_pe3isab_15_04 MP_62 (.D( D ), .B( SB ), .G( net20 ), .S( SB ));
ioh_pe3isab_15_04 MP_63 (.D( D ), .B( SB ), .G( net20 ), .S( SB ));
ioh_pe3isab_15_04 MP_64 (.D( D ), .B( SB ), .G( net20 ), .S( SB ));
ioh_pe3isab_15_04 MP_65 (.D( D ), .B( SB ), .G( net20 ), .S( SB ));
ioh_pe3isab_15_04 MP_66 (.D( D ), .B( SB ), .G( net20 ), .S( SB ));
ioh_pe3isab_15_04 MP_67 (.D( D ), .B( SB ), .G( net20 ), .S( SB ));
ioh_pe3isab_15_04 MP_68 (.D( D ), .B( SB ), .G( net20 ), .S( SB ));
ioh_pe3isab_15_04 MP_69 (.D( D ), .B( SB ), .G( net20 ), .S( SB ));
ioh_pe3isab_15_04 MP_70 (.D( D ), .B( SB ), .G( net20 ), .S( SB ));
dp3 #(.area(9.89102e-12), .perimeter(1.32e-06), .dbv(0), .m(1), .par1(1))
(* integer passed_mfactor = "m"; *)
 MD_1 (D, SB);
dp3 #(.area(9.89102e-12), .perimeter(1.32e-06), .dbv(0), .m(1), .par1(1))
(* integer passed_mfactor = "m"; *)
 MD_2 (D, SB);
dp3 #(.area(9.89102e-12), .perimeter(1.32e-06), .dbv(0), .m(1), .par1(1))
(* integer passed_mfactor = "m"; *)
 MD_3 (D, SB);
dp3 #(.area(9.89102e-12), .perimeter(1.32e-06), .dbv(0), .m(1), .par1(1))
(* integer passed_mfactor = "m"; *)
 MD_4 (D, SB);
dp3 #(.area(9.89102e-12), .perimeter(1.32e-06), .dbv(0), .m(1), .par1(1))
(* integer passed_mfactor = "m"; *)
 MD_5 (D, SB);
dp3 #(.area(9.89102e-12), .perimeter(1.32e-06), .dbv(0), .m(1), .par1(1))
(* integer passed_mfactor = "m"; *)
 MD_6 (D, SB);
dp3 #(.area(9.89102e-12), .perimeter(1.32e-06), .dbv(0), .m(1), .par1(1))
(* integer passed_mfactor = "m"; *)
 MD_7 (D, SB);
dp3 #(.area(9.89102e-12), .perimeter(1.32e-06), .dbv(0), .m(1), .par1(1))
(* integer passed_mfactor = "m"; *)
 MD_8 (D, SB);
dp3 #(.area(9.89102e-12), .perimeter(1.32e-06), .dbv(0), .m(1), .par1(1))
(* integer passed_mfactor = "m"; *)
 MD_9 (D, SB);
dp3 #(.area(9.89102e-12), .perimeter(1.32e-06), .dbv(0), .m(1), .par1(1))
(* integer passed_mfactor = "m"; *)
 MD_10 (D, SB);
dp3 #(.area(9.89102e-12), .perimeter(1.32e-06), .dbv(0), .m(1), .par1(1))
(* integer passed_mfactor = "m"; *)
 MD_11 (D, SB);
dp3 #(.area(9.89102e-12), .perimeter(1.32e-06), .dbv(0), .m(1), .par1(1))
(* integer passed_mfactor = "m"; *)
 MD_12 (D, SB);
dp3 #(.area(9.89102e-12), .perimeter(1.32e-06), .dbv(0), .m(1), .par1(1))
(* integer passed_mfactor = "m"; *)
 MD_13 (D, SB);
dp3 #(.area(9.89102e-12), .perimeter(1.32e-06), .dbv(0), .m(1), .par1(1))
(* integer passed_mfactor = "m"; *)
 MD_14 (D, SB);
dp3 #(.area(9.89102e-12), .perimeter(1.32e-06), .dbv(0), .m(1), .par1(1))
(* integer passed_mfactor = "m"; *)
 MD_15 (D, SB);
dp3 #(.area(9.89102e-12), .perimeter(1.32e-06), .dbv(0), .m(1), .par1(1))
(* integer passed_mfactor = "m"; *)
 MD_16 (D, SB);
dp3 #(.area(9.89102e-12), .perimeter(1.32e-06), .dbv(0), .m(1), .par1(1))
(* integer passed_mfactor = "m"; *)
 MD_17 (D, SB);
dp3 #(.area(9.89102e-12), .perimeter(1.32e-06), .dbv(0), .m(1), .par1(1))
(* integer passed_mfactor = "m"; *)
 MD_18 (D, SB);
dp3 #(.area(9.89102e-12), .perimeter(1.32e-06), .dbv(0), .m(1), .par1(1))
(* integer passed_mfactor = "m"; *)
 MD_19 (D, SB);
dp3 #(.area(9.89102e-12), .perimeter(1.32e-06), .dbv(0), .m(1), .par1(1))
(* integer passed_mfactor = "m"; *)
 MD_20 (D, SB);
dp3 #(.area(9.89102e-12), .perimeter(1.32e-06), .dbv(0), .m(1), .par1(1))
(* integer passed_mfactor = "m"; *)
 MD_21 (D, SB);
dp3 #(.area(9.89102e-12), .perimeter(1.32e-06), .dbv(0), .m(1), .par1(1))
(* integer passed_mfactor = "m"; *)
 MD_22 (D, SB);
dp3 #(.area(9.89102e-12), .perimeter(1.32e-06), .dbv(0), .m(1), .par1(1))
(* integer passed_mfactor = "m"; *)
 MD_23 (D, SB);
dp3 #(.area(9.89102e-12), .perimeter(1.32e-06), .dbv(0), .m(1), .par1(1))
(* integer passed_mfactor = "m"; *)
 MD_24 (D, SB);
dp3 #(.area(9.89102e-12), .perimeter(1.32e-06), .dbv(0), .m(1), .par1(1))
(* integer passed_mfactor = "m"; *)
 MD_25 (D, SB);
dp3 #(.area(9.89102e-12), .perimeter(1.32e-06), .dbv(0), .m(1), .par1(1))
(* integer passed_mfactor = "m"; *)
 MD_26 (D, SB);
dp3 #(.area(9.89102e-12), .perimeter(1.32e-06), .dbv(0), .m(1), .par1(1))
(* integer passed_mfactor = "m"; *)
 MD_27 (D, SB);
dp3 #(.area(9.89102e-12), .perimeter(1.32e-06), .dbv(0), .m(1), .par1(1))
(* integer passed_mfactor = "m"; *)
 MD_28 (D, SB);
dp3 #(.area(9.89102e-12), .perimeter(1.32e-06), .dbv(0), .m(1), .par1(1))
(* integer passed_mfactor = "m"; *)
 MD_29 (D, SB);
dp3 #(.area(9.89102e-12), .perimeter(1.32e-06), .dbv(0), .m(1), .par1(1))
(* integer passed_mfactor = "m"; *)
 MD_30 (D, SB);
dp3 #(.area(9.89102e-12), .perimeter(1.32e-06), .dbv(0), .m(1), .par1(1))
(* integer passed_mfactor = "m"; *)
 MD_31 (D, SB);
dp3 #(.area(9.89102e-12), .perimeter(1.32e-06), .dbv(0), .m(1), .par1(1))
(* integer passed_mfactor = "m"; *)
 MD_32 (D, SB);
dp3 #(.area(9.89102e-12), .perimeter(1.32e-06), .dbv(0), .m(1), .par1(1))
(* integer passed_mfactor = "m"; *)
 MD_33 (D, SB);
dp3 #(.area(9.89102e-12), .perimeter(1.32e-06), .dbv(0), .m(1), .par1(1))
(* integer passed_mfactor = "m"; *)
 MD_34 (D, SB);
dp3 #(.area(9.89102e-12), .perimeter(1.32e-06), .dbv(0), .m(1), .par1(1))
(* integer passed_mfactor = "m"; *)
 MD_35 (D, SB);
ddnw #(.area(3.10026e-09), .perimeter(0.0002852), .dbv(0), .m(1), .par1(1), .xf_subext(0))
(* integer passed_mfactor = "m"; *)
 D0 (Sub, SB);
rnp1 #(.l(2.55e-05), .w(4.2e-07), .m(1), .par1(1))
(* integer passed_mfactor = "m"; *)
 R0 (SB, net20);

endmodule
// Library - HV_CELLS, Cell - ioh_pmbsab_15_10, View - schematic
// LAST TIME SAVED: Feb 25 05:55:56 2015
// NETLIST TIME: Feb  9 05:16:35 2024

`worklib HV_CELLS
`view schematic

`timescale 1ns / 1ps
(* cds_ams_schematic *)

module ioh_pmbsab_15_10 (B, D, G, S);
inout  B, D, G, S;
pmb #(.w(1.512e-05), .l(1e-06), .as(7.2576e-12), .ad(7.2576e-12), .ps(3.12e-05), .pd(3.12e-05), .nrs(0.0178571), .nrd(0.0178571), .m((1)*(1)), .par1((1)*(1)))
(* integer passed_mfactor = "m"; *)
 MPX (D, G, S, B);

endmodule
// Library - HV_CELLS, Cell - ioh_pmbsabhv_750, View - schematic
// LAST TIME SAVED: Feb 25 05:55:57 2015
// NETLIST TIME: Feb  9 05:16:35 2024

`worklib HV_CELLS
`view schematic

`timescale 1ns / 1ps
(* cds_ams_schematic *)

module ioh_pmbsabhv_750 (D, GSB, Sub);
inout  D, GSB, Sub;
wire [0:49] net20;
ioh_pmbsab_15_10 MP_1 (.D( net20[0] ), .B( GSB ), .G( GSB ), .S( GSB ));
ioh_pmbsab_15_10 MP_2 (.D( net20[1] ), .B( GSB ), .G( GSB ), .S( GSB ));
ioh_pmbsab_15_10 MP_3 (.D( net20[2] ), .B( GSB ), .G( GSB ), .S( GSB ));
ioh_pmbsab_15_10 MP_4 (.D( net20[3] ), .B( GSB ), .G( GSB ), .S( GSB ));
ioh_pmbsab_15_10 MP_5 (.D( net20[4] ), .B( GSB ), .G( GSB ), .S( GSB ));
ioh_pmbsab_15_10 MP_6 (.D( net20[5] ), .B( GSB ), .G( GSB ), .S( GSB ));
ioh_pmbsab_15_10 MP_7 (.D( net20[6] ), .B( GSB ), .G( GSB ), .S( GSB ));
ioh_pmbsab_15_10 MP_8 (.D( net20[7] ), .B( GSB ), .G( GSB ), .S( GSB ));
ioh_pmbsab_15_10 MP_9 (.D( net20[8] ), .B( GSB ), .G( GSB ), .S( GSB ));
ioh_pmbsab_15_10 MP_10 (.D( net20[9] ), .B( GSB ), .G( GSB ), .S( GSB ));
ioh_pmbsab_15_10 MP_11 (.D( net20[10] ), .B( GSB ), .G( GSB ), .S( GSB ));
ioh_pmbsab_15_10 MP_12 (.D( net20[11] ), .B( GSB ), .G( GSB ), .S( GSB ));
ioh_pmbsab_15_10 MP_13 (.D( net20[12] ), .B( GSB ), .G( GSB ), .S( GSB ));
ioh_pmbsab_15_10 MP_14 (.D( net20[13] ), .B( GSB ), .G( GSB ), .S( GSB ));
ioh_pmbsab_15_10 MP_15 (.D( net20[14] ), .B( GSB ), .G( GSB ), .S( GSB ));
ioh_pmbsab_15_10 MP_16 (.D( net20[15] ), .B( GSB ), .G( GSB ), .S( GSB ));
ioh_pmbsab_15_10 MP_17 (.D( net20[16] ), .B( GSB ), .G( GSB ), .S( GSB ));
ioh_pmbsab_15_10 MP_18 (.D( net20[17] ), .B( GSB ), .G( GSB ), .S( GSB ));
ioh_pmbsab_15_10 MP_19 (.D( net20[18] ), .B( GSB ), .G( GSB ), .S( GSB ));
ioh_pmbsab_15_10 MP_20 (.D( net20[19] ), .B( GSB ), .G( GSB ), .S( GSB ));
ioh_pmbsab_15_10 MP_21 (.D( net20[20] ), .B( GSB ), .G( GSB ), .S( GSB ));
ioh_pmbsab_15_10 MP_22 (.D( net20[21] ), .B( GSB ), .G( GSB ), .S( GSB ));
ioh_pmbsab_15_10 MP_23 (.D( net20[22] ), .B( GSB ), .G( GSB ), .S( GSB ));
ioh_pmbsab_15_10 MP_24 (.D( net20[23] ), .B( GSB ), .G( GSB ), .S( GSB ));
ioh_pmbsab_15_10 MP_25 (.D( net20[24] ), .B( GSB ), .G( GSB ), .S( GSB ));
ioh_pmbsab_15_10 MP_26 (.D( net20[25] ), .B( GSB ), .G( GSB ), .S( GSB ));
ioh_pmbsab_15_10 MP_27 (.D( net20[26] ), .B( GSB ), .G( GSB ), .S( GSB ));
ioh_pmbsab_15_10 MP_28 (.D( net20[27] ), .B( GSB ), .G( GSB ), .S( GSB ));
ioh_pmbsab_15_10 MP_29 (.D( net20[28] ), .B( GSB ), .G( GSB ), .S( GSB ));
ioh_pmbsab_15_10 MP_30 (.D( net20[29] ), .B( GSB ), .G( GSB ), .S( GSB ));
ioh_pmbsab_15_10 MP_31 (.D( net20[30] ), .B( GSB ), .G( GSB ), .S( GSB ));
ioh_pmbsab_15_10 MP_32 (.D( net20[31] ), .B( GSB ), .G( GSB ), .S( GSB ));
ioh_pmbsab_15_10 MP_33 (.D( net20[32] ), .B( GSB ), .G( GSB ), .S( GSB ));
ioh_pmbsab_15_10 MP_34 (.D( net20[33] ), .B( GSB ), .G( GSB ), .S( GSB ));
ioh_pmbsab_15_10 MP_35 (.D( net20[34] ), .B( GSB ), .G( GSB ), .S( GSB ));
ioh_pmbsab_15_10 MP_36 (.D( net20[35] ), .B( GSB ), .G( GSB ), .S( GSB ));
ioh_pmbsab_15_10 MP_37 (.D( net20[36] ), .B( GSB ), .G( GSB ), .S( GSB ));
ioh_pmbsab_15_10 MP_38 (.D( net20[37] ), .B( GSB ), .G( GSB ), .S( GSB ));
ioh_pmbsab_15_10 MP_39 (.D( net20[38] ), .B( GSB ), .G( GSB ), .S( GSB ));
ioh_pmbsab_15_10 MP_40 (.D( net20[39] ), .B( GSB ), .G( GSB ), .S( GSB ));
ioh_pmbsab_15_10 MP_41 (.D( net20[40] ), .B( GSB ), .G( GSB ), .S( GSB ));
ioh_pmbsab_15_10 MP_42 (.D( net20[41] ), .B( GSB ), .G( GSB ), .S( GSB ));
ioh_pmbsab_15_10 MP_43 (.D( net20[42] ), .B( GSB ), .G( GSB ), .S( GSB ));
ioh_pmbsab_15_10 MP_44 (.D( net20[43] ), .B( GSB ), .G( GSB ), .S( GSB ));
ioh_pmbsab_15_10 MP_45 (.D( net20[44] ), .B( GSB ), .G( GSB ), .S( GSB ));
ioh_pmbsab_15_10 MP_46 (.D( net20[45] ), .B( GSB ), .G( GSB ), .S( GSB ));
ioh_pmbsab_15_10 MP_47 (.D( net20[46] ), .B( GSB ), .G( GSB ), .S( GSB ));
ioh_pmbsab_15_10 MP_48 (.D( net20[47] ), .B( GSB ), .G( GSB ), .S( GSB ));
ioh_pmbsab_15_10 MP_49 (.D( net20[48] ), .B( GSB ), .G( GSB ), .S( GSB ));
ioh_pmbsab_15_10 MP_50 (.D( net20[49] ), .B( GSB ), .G( GSB ), .S( GSB ));
rdp_io #(.l(5.1e-07), .w(1.5e-05), .m(1), .par1(1), .xf_subext(0))
(* integer passed_mfactor = "m"; *)
 R0_1 (net20[0], D, GSB);
rdp_io #(.l(5.1e-07), .w(1.5e-05), .m(1), .par1(1), .xf_subext(0))
(* integer passed_mfactor = "m"; *)
 R0_2 (net20[1], D, GSB);
rdp_io #(.l(5.1e-07), .w(1.5e-05), .m(1), .par1(1), .xf_subext(0))
(* integer passed_mfactor = "m"; *)
 R0_3 (net20[2], D, GSB);
rdp_io #(.l(5.1e-07), .w(1.5e-05), .m(1), .par1(1), .xf_subext(0))
(* integer passed_mfactor = "m"; *)
 R0_4 (net20[3], D, GSB);
rdp_io #(.l(5.1e-07), .w(1.5e-05), .m(1), .par1(1), .xf_subext(0))
(* integer passed_mfactor = "m"; *)
 R0_5 (net20[4], D, GSB);
rdp_io #(.l(5.1e-07), .w(1.5e-05), .m(1), .par1(1), .xf_subext(0))
(* integer passed_mfactor = "m"; *)
 R0_6 (net20[5], D, GSB);
rdp_io #(.l(5.1e-07), .w(1.5e-05), .m(1), .par1(1), .xf_subext(0))
(* integer passed_mfactor = "m"; *)
 R0_7 (net20[6], D, GSB);
rdp_io #(.l(5.1e-07), .w(1.5e-05), .m(1), .par1(1), .xf_subext(0))
(* integer passed_mfactor = "m"; *)
 R0_8 (net20[7], D, GSB);
rdp_io #(.l(5.1e-07), .w(1.5e-05), .m(1), .par1(1), .xf_subext(0))
(* integer passed_mfactor = "m"; *)
 R0_9 (net20[8], D, GSB);
rdp_io #(.l(5.1e-07), .w(1.5e-05), .m(1), .par1(1), .xf_subext(0))
(* integer passed_mfactor = "m"; *)
 R0_10 (net20[9], D, GSB);
rdp_io #(.l(5.1e-07), .w(1.5e-05), .m(1), .par1(1), .xf_subext(0))
(* integer passed_mfactor = "m"; *)
 R0_11 (net20[10], D, GSB);
rdp_io #(.l(5.1e-07), .w(1.5e-05), .m(1), .par1(1), .xf_subext(0))
(* integer passed_mfactor = "m"; *)
 R0_12 (net20[11], D, GSB);
rdp_io #(.l(5.1e-07), .w(1.5e-05), .m(1), .par1(1), .xf_subext(0))
(* integer passed_mfactor = "m"; *)
 R0_13 (net20[12], D, GSB);
rdp_io #(.l(5.1e-07), .w(1.5e-05), .m(1), .par1(1), .xf_subext(0))
(* integer passed_mfactor = "m"; *)
 R0_14 (net20[13], D, GSB);
rdp_io #(.l(5.1e-07), .w(1.5e-05), .m(1), .par1(1), .xf_subext(0))
(* integer passed_mfactor = "m"; *)
 R0_15 (net20[14], D, GSB);
rdp_io #(.l(5.1e-07), .w(1.5e-05), .m(1), .par1(1), .xf_subext(0))
(* integer passed_mfactor = "m"; *)
 R0_16 (net20[15], D, GSB);
rdp_io #(.l(5.1e-07), .w(1.5e-05), .m(1), .par1(1), .xf_subext(0))
(* integer passed_mfactor = "m"; *)
 R0_17 (net20[16], D, GSB);
rdp_io #(.l(5.1e-07), .w(1.5e-05), .m(1), .par1(1), .xf_subext(0))
(* integer passed_mfactor = "m"; *)
 R0_18 (net20[17], D, GSB);
rdp_io #(.l(5.1e-07), .w(1.5e-05), .m(1), .par1(1), .xf_subext(0))
(* integer passed_mfactor = "m"; *)
 R0_19 (net20[18], D, GSB);
rdp_io #(.l(5.1e-07), .w(1.5e-05), .m(1), .par1(1), .xf_subext(0))
(* integer passed_mfactor = "m"; *)
 R0_20 (net20[19], D, GSB);
rdp_io #(.l(5.1e-07), .w(1.5e-05), .m(1), .par1(1), .xf_subext(0))
(* integer passed_mfactor = "m"; *)
 R0_21 (net20[20], D, GSB);
rdp_io #(.l(5.1e-07), .w(1.5e-05), .m(1), .par1(1), .xf_subext(0))
(* integer passed_mfactor = "m"; *)
 R0_22 (net20[21], D, GSB);
rdp_io #(.l(5.1e-07), .w(1.5e-05), .m(1), .par1(1), .xf_subext(0))
(* integer passed_mfactor = "m"; *)
 R0_23 (net20[22], D, GSB);
rdp_io #(.l(5.1e-07), .w(1.5e-05), .m(1), .par1(1), .xf_subext(0))
(* integer passed_mfactor = "m"; *)
 R0_24 (net20[23], D, GSB);
rdp_io #(.l(5.1e-07), .w(1.5e-05), .m(1), .par1(1), .xf_subext(0))
(* integer passed_mfactor = "m"; *)
 R0_25 (net20[24], D, GSB);
rdp_io #(.l(5.1e-07), .w(1.5e-05), .m(1), .par1(1), .xf_subext(0))
(* integer passed_mfactor = "m"; *)
 R0_26 (net20[25], D, GSB);
rdp_io #(.l(5.1e-07), .w(1.5e-05), .m(1), .par1(1), .xf_subext(0))
(* integer passed_mfactor = "m"; *)
 R0_27 (net20[26], D, GSB);
rdp_io #(.l(5.1e-07), .w(1.5e-05), .m(1), .par1(1), .xf_subext(0))
(* integer passed_mfactor = "m"; *)
 R0_28 (net20[27], D, GSB);
rdp_io #(.l(5.1e-07), .w(1.5e-05), .m(1), .par1(1), .xf_subext(0))
(* integer passed_mfactor = "m"; *)
 R0_29 (net20[28], D, GSB);
rdp_io #(.l(5.1e-07), .w(1.5e-05), .m(1), .par1(1), .xf_subext(0))
(* integer passed_mfactor = "m"; *)
 R0_30 (net20[29], D, GSB);
rdp_io #(.l(5.1e-07), .w(1.5e-05), .m(1), .par1(1), .xf_subext(0))
(* integer passed_mfactor = "m"; *)
 R0_31 (net20[30], D, GSB);
rdp_io #(.l(5.1e-07), .w(1.5e-05), .m(1), .par1(1), .xf_subext(0))
(* integer passed_mfactor = "m"; *)
 R0_32 (net20[31], D, GSB);
rdp_io #(.l(5.1e-07), .w(1.5e-05), .m(1), .par1(1), .xf_subext(0))
(* integer passed_mfactor = "m"; *)
 R0_33 (net20[32], D, GSB);
rdp_io #(.l(5.1e-07), .w(1.5e-05), .m(1), .par1(1), .xf_subext(0))
(* integer passed_mfactor = "m"; *)
 R0_34 (net20[33], D, GSB);
rdp_io #(.l(5.1e-07), .w(1.5e-05), .m(1), .par1(1), .xf_subext(0))
(* integer passed_mfactor = "m"; *)
 R0_35 (net20[34], D, GSB);
rdp_io #(.l(5.1e-07), .w(1.5e-05), .m(1), .par1(1), .xf_subext(0))
(* integer passed_mfactor = "m"; *)
 R0_36 (net20[35], D, GSB);
rdp_io #(.l(5.1e-07), .w(1.5e-05), .m(1), .par1(1), .xf_subext(0))
(* integer passed_mfactor = "m"; *)
 R0_37 (net20[36], D, GSB);
rdp_io #(.l(5.1e-07), .w(1.5e-05), .m(1), .par1(1), .xf_subext(0))
(* integer passed_mfactor = "m"; *)
 R0_38 (net20[37], D, GSB);
rdp_io #(.l(5.1e-07), .w(1.5e-05), .m(1), .par1(1), .xf_subext(0))
(* integer passed_mfactor = "m"; *)
 R0_39 (net20[38], D, GSB);
rdp_io #(.l(5.1e-07), .w(1.5e-05), .m(1), .par1(1), .xf_subext(0))
(* integer passed_mfactor = "m"; *)
 R0_40 (net20[39], D, GSB);
rdp_io #(.l(5.1e-07), .w(1.5e-05), .m(1), .par1(1), .xf_subext(0))
(* integer passed_mfactor = "m"; *)
 R0_41 (net20[40], D, GSB);
rdp_io #(.l(5.1e-07), .w(1.5e-05), .m(1), .par1(1), .xf_subext(0))
(* integer passed_mfactor = "m"; *)
 R0_42 (net20[41], D, GSB);
rdp_io #(.l(5.1e-07), .w(1.5e-05), .m(1), .par1(1), .xf_subext(0))
(* integer passed_mfactor = "m"; *)
 R0_43 (net20[42], D, GSB);
rdp_io #(.l(5.1e-07), .w(1.5e-05), .m(1), .par1(1), .xf_subext(0))
(* integer passed_mfactor = "m"; *)
 R0_44 (net20[43], D, GSB);
rdp_io #(.l(5.1e-07), .w(1.5e-05), .m(1), .par1(1), .xf_subext(0))
(* integer passed_mfactor = "m"; *)
 R0_45 (net20[44], D, GSB);
rdp_io #(.l(5.1e-07), .w(1.5e-05), .m(1), .par1(1), .xf_subext(0))
(* integer passed_mfactor = "m"; *)
 R0_46 (net20[45], D, GSB);
rdp_io #(.l(5.1e-07), .w(1.5e-05), .m(1), .par1(1), .xf_subext(0))
(* integer passed_mfactor = "m"; *)
 R0_47 (net20[46], D, GSB);
rdp_io #(.l(5.1e-07), .w(1.5e-05), .m(1), .par1(1), .xf_subext(0))
(* integer passed_mfactor = "m"; *)
 R0_48 (net20[47], D, GSB);
rdp_io #(.l(5.1e-07), .w(1.5e-05), .m(1), .par1(1), .xf_subext(0))
(* integer passed_mfactor = "m"; *)
 R0_49 (net20[48], D, GSB);
rdp_io #(.l(5.1e-07), .w(1.5e-05), .m(1), .par1(1), .xf_subext(0))
(* integer passed_mfactor = "m"; *)
 R0_50 (net20[49], D, GSB);
dphnw #(.area(4.95062e-12), .perimeter(6.6e-07), .dbv(0), .m(1), .par1(1))
(* integer passed_mfactor = "m"; *)
 D0_1 (D, GSB);
dphnw #(.area(4.95062e-12), .perimeter(6.6e-07), .dbv(0), .m(1), .par1(1))
(* integer passed_mfactor = "m"; *)
 D0_2 (D, GSB);
dphnw #(.area(4.95062e-12), .perimeter(6.6e-07), .dbv(0), .m(1), .par1(1))
(* integer passed_mfactor = "m"; *)
 D0_3 (D, GSB);
dphnw #(.area(4.95062e-12), .perimeter(6.6e-07), .dbv(0), .m(1), .par1(1))
(* integer passed_mfactor = "m"; *)
 D0_4 (D, GSB);
dphnw #(.area(4.95062e-12), .perimeter(6.6e-07), .dbv(0), .m(1), .par1(1))
(* integer passed_mfactor = "m"; *)
 D0_5 (D, GSB);
dphnw #(.area(4.95062e-12), .perimeter(6.6e-07), .dbv(0), .m(1), .par1(1))
(* integer passed_mfactor = "m"; *)
 D0_6 (D, GSB);
dphnw #(.area(4.95062e-12), .perimeter(6.6e-07), .dbv(0), .m(1), .par1(1))
(* integer passed_mfactor = "m"; *)
 D0_7 (D, GSB);
dphnw #(.area(4.95062e-12), .perimeter(6.6e-07), .dbv(0), .m(1), .par1(1))
(* integer passed_mfactor = "m"; *)
 D0_8 (D, GSB);
dphnw #(.area(4.95062e-12), .perimeter(6.6e-07), .dbv(0), .m(1), .par1(1))
(* integer passed_mfactor = "m"; *)
 D0_9 (D, GSB);
dphnw #(.area(4.95062e-12), .perimeter(6.6e-07), .dbv(0), .m(1), .par1(1))
(* integer passed_mfactor = "m"; *)
 D0_10 (D, GSB);
dphnw #(.area(4.95062e-12), .perimeter(6.6e-07), .dbv(0), .m(1), .par1(1))
(* integer passed_mfactor = "m"; *)
 D0_11 (D, GSB);
dphnw #(.area(4.95062e-12), .perimeter(6.6e-07), .dbv(0), .m(1), .par1(1))
(* integer passed_mfactor = "m"; *)
 D0_12 (D, GSB);
dphnw #(.area(4.95062e-12), .perimeter(6.6e-07), .dbv(0), .m(1), .par1(1))
(* integer passed_mfactor = "m"; *)
 D0_13 (D, GSB);
dphnw #(.area(4.95062e-12), .perimeter(6.6e-07), .dbv(0), .m(1), .par1(1))
(* integer passed_mfactor = "m"; *)
 D0_14 (D, GSB);
dphnw #(.area(4.95062e-12), .perimeter(6.6e-07), .dbv(0), .m(1), .par1(1))
(* integer passed_mfactor = "m"; *)
 D0_15 (D, GSB);
dphnw #(.area(4.95062e-12), .perimeter(6.6e-07), .dbv(0), .m(1), .par1(1))
(* integer passed_mfactor = "m"; *)
 D0_16 (D, GSB);
dphnw #(.area(4.95062e-12), .perimeter(6.6e-07), .dbv(0), .m(1), .par1(1))
(* integer passed_mfactor = "m"; *)
 D0_17 (D, GSB);
dphnw #(.area(4.95062e-12), .perimeter(6.6e-07), .dbv(0), .m(1), .par1(1))
(* integer passed_mfactor = "m"; *)
 D0_18 (D, GSB);
dphnw #(.area(4.95062e-12), .perimeter(6.6e-07), .dbv(0), .m(1), .par1(1))
(* integer passed_mfactor = "m"; *)
 D0_19 (D, GSB);
dphnw #(.area(4.95062e-12), .perimeter(6.6e-07), .dbv(0), .m(1), .par1(1))
(* integer passed_mfactor = "m"; *)
 D0_20 (D, GSB);
dphnw #(.area(4.95062e-12), .perimeter(6.6e-07), .dbv(0), .m(1), .par1(1))
(* integer passed_mfactor = "m"; *)
 D0_21 (D, GSB);
dphnw #(.area(4.95062e-12), .perimeter(6.6e-07), .dbv(0), .m(1), .par1(1))
(* integer passed_mfactor = "m"; *)
 D0_22 (D, GSB);
dphnw #(.area(4.95062e-12), .perimeter(6.6e-07), .dbv(0), .m(1), .par1(1))
(* integer passed_mfactor = "m"; *)
 D0_23 (D, GSB);
dphnw #(.area(4.95062e-12), .perimeter(6.6e-07), .dbv(0), .m(1), .par1(1))
(* integer passed_mfactor = "m"; *)
 D0_24 (D, GSB);
dphnw #(.area(4.95062e-12), .perimeter(6.6e-07), .dbv(0), .m(1), .par1(1))
(* integer passed_mfactor = "m"; *)
 D0_25 (D, GSB);
dphnw #(.area(4.95062e-12), .perimeter(6.6e-07), .dbv(0), .m(1), .par1(1))
(* integer passed_mfactor = "m"; *)
 D0_26 (D, GSB);
dphnw #(.area(4.95062e-12), .perimeter(6.6e-07), .dbv(0), .m(1), .par1(1))
(* integer passed_mfactor = "m"; *)
 D0_27 (D, GSB);
dphnw #(.area(4.95062e-12), .perimeter(6.6e-07), .dbv(0), .m(1), .par1(1))
(* integer passed_mfactor = "m"; *)
 D0_28 (D, GSB);
dphnw #(.area(4.95062e-12), .perimeter(6.6e-07), .dbv(0), .m(1), .par1(1))
(* integer passed_mfactor = "m"; *)
 D0_29 (D, GSB);
dphnw #(.area(4.95062e-12), .perimeter(6.6e-07), .dbv(0), .m(1), .par1(1))
(* integer passed_mfactor = "m"; *)
 D0_30 (D, GSB);
dphnw #(.area(4.95062e-12), .perimeter(6.6e-07), .dbv(0), .m(1), .par1(1))
(* integer passed_mfactor = "m"; *)
 D0_31 (D, GSB);
dphnw #(.area(4.95062e-12), .perimeter(6.6e-07), .dbv(0), .m(1), .par1(1))
(* integer passed_mfactor = "m"; *)
 D0_32 (D, GSB);
dphnw #(.area(4.95062e-12), .perimeter(6.6e-07), .dbv(0), .m(1), .par1(1))
(* integer passed_mfactor = "m"; *)
 D0_33 (D, GSB);
dphnw #(.area(4.95062e-12), .perimeter(6.6e-07), .dbv(0), .m(1), .par1(1))
(* integer passed_mfactor = "m"; *)
 D0_34 (D, GSB);
dphnw #(.area(4.95062e-12), .perimeter(6.6e-07), .dbv(0), .m(1), .par1(1))
(* integer passed_mfactor = "m"; *)
 D0_35 (D, GSB);
dphnw #(.area(4.95062e-12), .perimeter(6.6e-07), .dbv(0), .m(1), .par1(1))
(* integer passed_mfactor = "m"; *)
 D0_36 (D, GSB);
dphnw #(.area(4.95062e-12), .perimeter(6.6e-07), .dbv(0), .m(1), .par1(1))
(* integer passed_mfactor = "m"; *)
 D0_37 (D, GSB);
dphnw #(.area(4.95062e-12), .perimeter(6.6e-07), .dbv(0), .m(1), .par1(1))
(* integer passed_mfactor = "m"; *)
 D0_38 (D, GSB);
dphnw #(.area(4.95062e-12), .perimeter(6.6e-07), .dbv(0), .m(1), .par1(1))
(* integer passed_mfactor = "m"; *)
 D0_39 (D, GSB);
dphnw #(.area(4.95062e-12), .perimeter(6.6e-07), .dbv(0), .m(1), .par1(1))
(* integer passed_mfactor = "m"; *)
 D0_40 (D, GSB);
dphnw #(.area(4.95062e-12), .perimeter(6.6e-07), .dbv(0), .m(1), .par1(1))
(* integer passed_mfactor = "m"; *)
 D0_41 (D, GSB);
dphnw #(.area(4.95062e-12), .perimeter(6.6e-07), .dbv(0), .m(1), .par1(1))
(* integer passed_mfactor = "m"; *)
 D0_42 (D, GSB);
dphnw #(.area(4.95062e-12), .perimeter(6.6e-07), .dbv(0), .m(1), .par1(1))
(* integer passed_mfactor = "m"; *)
 D0_43 (D, GSB);
dphnw #(.area(4.95062e-12), .perimeter(6.6e-07), .dbv(0), .m(1), .par1(1))
(* integer passed_mfactor = "m"; *)
 D0_44 (D, GSB);
dphnw #(.area(4.95062e-12), .perimeter(6.6e-07), .dbv(0), .m(1), .par1(1))
(* integer passed_mfactor = "m"; *)
 D0_45 (D, GSB);
dphnw #(.area(4.95062e-12), .perimeter(6.6e-07), .dbv(0), .m(1), .par1(1))
(* integer passed_mfactor = "m"; *)
 D0_46 (D, GSB);
dphnw #(.area(4.95062e-12), .perimeter(6.6e-07), .dbv(0), .m(1), .par1(1))
(* integer passed_mfactor = "m"; *)
 D0_47 (D, GSB);
dphnw #(.area(4.95062e-12), .perimeter(6.6e-07), .dbv(0), .m(1), .par1(1))
(* integer passed_mfactor = "m"; *)
 D0_48 (D, GSB);
dphnw #(.area(4.95062e-12), .perimeter(6.6e-07), .dbv(0), .m(1), .par1(1))
(* integer passed_mfactor = "m"; *)
 D0_49 (D, GSB);
dphnw #(.area(4.95062e-12), .perimeter(6.6e-07), .dbv(0), .m(1), .par1(1))
(* integer passed_mfactor = "m"; *)
 D0_50 (D, GSB);
ddnw #(.area(3.03711e-09), .perimeter(0.000284), .dbv(0), .m(1), .par1(1), .xf_subext(0))
(* integer passed_mfactor = "m"; *)
 D1 (Sub, GSB);

endmodule
// Library - HV_CELLS, Cell - ioh_c5pk, View - schematic
// LAST TIME SAVED: Feb 25 05:56:12 2015
// NETLIST TIME: Feb  9 05:16:35 2024

`worklib HV_CELLS
`view schematic

`timescale 1ns / 1ps
(* cds_ams_schematic *)

module ioh_c5pk (A_l, K_h, Sub);
inout  A_l, K_h, Sub;
wire net30;
wire net26;
wire net23;
wire net20;
ioh_pe3isabhv_1050gcr I5 (.Sub( Sub ), .SB( net30 ), .D( A_l ));
ioh_pmbsabhv_750 I3 (.Sub( Sub ), .D( net23 ), .GSB( net26 ));
ioh_pmbsabhv_750 I4 (.Sub( Sub ), .D( net30 ), .GSB( net23 ));
ioh_pmbsabhv_750 I2 (.Sub( Sub ), .D( net26 ), .GSB( net20 ));
ioh_pmbsabhv_750 I1 (.Sub( Sub ), .D( net20 ), .GSB( K_h ));

endmodule
// Library - HV_CELLS, Cell - HVD4SJD1R5PKFs, View - schematic
// LAST TIME SAVED: Feb 25 05:55:34 2015
// NETLIST TIME: Feb  9 05:16:35 2024

`worklib HV_CELLS
`view schematic

`timescale 1ns / 1ps
(* cds_ams_schematic *)

module HVD4SJD1R5PKFs (GNDO, IGND, PAD);
inout  GNDO, IGND, PAD;
wire Trig_0;
ioh_iscrd2_4x100 I10 (.Gp( Trig_0 ), .Sub( GNDO ), .A( PAD ), .Gn( PAD ), .K( IGND ));
ioh_dhpw_2x100_stack3 I9 (.A_l( IGND ), .Sub( GNDO ), .K_h( PAD ));
ioh_c5pk I11 (.Sub( GNDO ), .K_h( PAD ), .A_l( Trig_0 ));
rpp1s #(.l(1.6e-05), .w(0.0001), .m(1), .par1(1))
(* integer passed_mfactor = "m"; *)
 R4 (IGND, Trig_0);

endmodule
// Library - IORING, Cell - ioring, View - schematic
// LAST TIME SAVED: Feb  7 11:24:12 2024
// NETLIST TIME: Feb  9 05:16:35 2024

`worklib IORING
`view schematic

`timescale 1ns / 1ps
(* cds_ams_schematic *)

module ioring (CLK, ENABLE, GNDA, GNDD, GNDHV, GNDOHV, GNDOR, GNDORA, INL, OUT0, OUT1, OUT2, OUTHV, OUTL, PSUB, RESET, VDDA, VDDD, VDDHV, VDDOR, VDDORA, clk_core, enable_core, inl_core, out0_core, out1_core, out2_core, reset_core);
inout  CLK, ENABLE, GNDA, GNDD, GNDHV, GNDOHV, GNDOR, GNDORA, INL, OUT0, OUT1, OUT2, OUTHV, OUTL, PSUB, RESET, VDDA, VDDD, VDDHV, VDDOR, VDDORA, clk_core, enable_core, inl_core, out0_core, out1_core, out2_core, reset_core;
wire net4;
wire net3;
wire net1;
wire net10;
wire net11;
wire net14;
wire net15;
wire net12;
wire net16;
wire net9;
wire net8;
wire net2;
wire net6;
wire net5;
VDDORPADPC I18 (.PSUB( PSUB ), .GNDRI( GNDORA ), .VDD3I( VDDA ), .GNDI( GNDA ), .VDDORI( VDDORA ), .GNDOI( GNDORA ));
VDDORPADPC I1 (.PSUB( PSUB ), .GNDRI( GNDOR ), .VDD3I( VDDD ), .GNDI( GNDD ), .VDDORI( VDDOR ), .GNDOI( GNDOR ));
VDDPADPC I21 (.PSUB( PSUB ), .VDD3I( VDDA ), .GNDI( GNDA ), .VDDRI( VDDOR ), .GNDOI( GNDORA ), .VDDOI( VDDOR ), .GNDRI( GNDORA ));
VDDPADPC I3 (.PSUB( PSUB ), .VDD3I( VDDD ), .GNDI( GNDD ), .VDDRI( VDDOR ), .GNDOI( GNDOR ), .VDDOI( VDDOR ), .GNDRI( GNDOR ));
GNDORPADPC I20 (.VDDOI( VDDORA ), .GNDI( GNDA ), .VDD3I( VDDA ), .GNDORI( GNDORA ), .VDDRI( VDDORA ), .PSUB( PSUB ));
GNDORPADPC I0 (.VDDOI( VDDOR ), .GNDI( GNDD ), .VDD3I( VDDD ), .GNDORI( GNDOR ), .VDDRI( VDDOR ), .PSUB( PSUB ));
PSUBPADPC I4 (.VDDOI( VDDOR ), .PSUB( PSUB ), .VDD3I( VDDD ), .GNDI( GNDD ), .VDDRI( VDDOR ), .GNDOI( GNDOR ), .GNDRI( GNDOR ));
GNDPADPC I19 (.PSUB( PSUB ), .VDD3I( VDDA ), .GNDI( GNDA ), .VDDRI( VDDORA ), .GNDOI( GNDORA ), .VDDOI( VDDORA ), .GNDRI( GNDORA ));
GNDPADPC I5 (.PSUB( PSUB ), .VDD3I( VDDD ), .GNDI( GNDD ), .VDDRI( VDDOR ), .GNDOI( GNDOR ), .VDDOI( VDDOR ), .GNDRI( GNDOR ));
ICPC I11 (.VDD3I( VDDD ), .GNDI( GNDD ), .GNDRI( GNDOR ), .VDDRI( VDDOR ), .VDDOI( VDDOR ), .PSUB( PSUB ), .GNDOI( GNDOR ), .Y( reset_core ), .PAD( RESET ), .PI( GNDD ), .PO( net4 ));
ICPC I10 (.VDD3I( VDDD ), .GNDI( GNDD ), .GNDRI( GNDOR ), .VDDRI( VDDOR ), .VDDOI( VDDOR ), .PSUB( PSUB ), .GNDOI( GNDOR ), .Y( clk_core ), .PAD( CLK ), .PI( GNDD ), .PO( net3 ));
ICPC I9 (.VDD3I( VDDD ), .GNDI( GNDD ), .GNDRI( GNDOR ), .VDDRI( VDDOR ), .VDDOI( VDDOR ), .PSUB( PSUB ), .GNDOI( GNDOR ), .Y( enable_core ), .PAD( ENABLE ), .PI( GNDD ), .PO( net1 ));
PWRCUTDCPC I35 (.VDD3I1( net16 ), .GNDRI2( GNDOR ), .VDDOI2( VDDOR ), .GNDOI2( GNDOR ), .GNDI2( GNDD ), .VDDRI2( VDDOR ), .VDDOI1( net12 ), .GNDOI1( GNDOHV ), .VDDRI1( net15 ), .PSUB( net14 ), .VDD3I2( VDDD ), .GNDRI1( net11 ), .GNDI1( net10 ));
PWRCUTDCPC I34 (.VDD3I1( VDDA ), .GNDRI2( net5 ), .VDDOI2( net6 ), .GNDOI2( GNDOHV ), .GNDI2( net2 ), .VDDRI2( net8 ), .VDDOI1( VDDORA ), .GNDOI1( GNDORA ), .VDDRI1( VDDORA ), .PSUB( PSUB ), .VDD3I2( net9 ), .GNDRI1( GNDORA ), .GNDI1( GNDA ));
PWRCUTDCPC I12 (.VDD3I1( VDDD ), .GNDRI2( GNDORA ), .VDDOI2( VDDORA ), .GNDOI2( GNDORA ), .GNDI2( GNDA ), .VDDRI2( VDDORA ), .VDDOI1( VDDOR ), .GNDOI1( GNDOR ), .VDDRI1( VDDOR ), .PSUB( PSUB ), .VDD3I2( VDDA ), .GNDRI1( GNDOR ), .GNDI1( GNDD ));
BT4PC I17 (.PAD( OUT2 ), .A( out2_core ), .EN( GNDD ), .GNDRI( GNDOR ), .PSUB( PSUB ), .VDD3I( VDDD ), .GNDI( GNDD ), .GNDOI( GNDOR ), .VDDOI( VDDOR ), .VDDRI( VDDOR ));
BT4PC I16 (.PAD( OUT1 ), .A( out1_core ), .EN( GNDD ), .GNDRI( GNDOR ), .PSUB( PSUB ), .VDD3I( VDDD ), .GNDI( GNDD ), .GNDOI( GNDOR ), .VDDOI( VDDOR ), .VDDRI( VDDOR ));
BT4PC I15 (.PAD( OUT0 ), .A( out0_core ), .EN( GNDD ), .GNDRI( GNDOR ), .PSUB( PSUB ), .VDD3I( VDDD ), .GNDI( GNDD ), .GNDOI( GNDOR ), .VDDOI( VDDOR ), .VDDRI( VDDOR ));
APR04DPC I22 (.VDDRI( VDDORA ), .VDD3I( VDDA ), .VDDOI( VDDORA ), .PSUB( PSUB ), .GNDRI( GNDORA ), .GNDI( GNDA ), .GNDOI( GNDORA ), .Y( inl_core ), .PAD( INL ));
APR00DPC I23 (.VDD3I( VDDA ), .VDDOI( VDDORA ), .GNDRI( GNDORA ), .GNDI( GNDA ), .PSUB( PSUB ), .VDDRI( VDDORA ), .GNDOI( GNDORA ), .PAD( OUTL ));
HVDD4DJ5PKFs I24 (.PAD( VDDHV ), .GNDO( GNDOHV ), .IGND( GNDHV ));
HVDD4D2PK I36 (.PAD( GNDHV ), .GND( GNDOHV ));
HVD4SJD1R5PKFs I33 (.IGND( GNDHV ), .GNDO( GNDOHV ), .PAD( OUTHV ));

endmodule
// Library - INV_LP, Cell - inv, View - schematic
// LAST TIME SAVED: Feb  4 10:15:33 2024
// NETLIST TIME: Feb  9 05:16:35 2024

`worklib INV_LP
`view schematic

`timescale 1ns / 1ps
(* cds_ams_schematic *)

module inv (IN, OUT, VD, VS);
inout  IN, OUT, VD, VS;
ne3 #(.w(2e-06), .l(3.5e-07), .as(9.6e-13), .ad(9.6e-13), .ps(4.96e-06), .pd(4.96e-06), .nrs(0.135), .nrd(0.135), .m((1)*(1)), .par1((1)*(1)), .xf_subext(0))
(* integer passed_mfactor = "m"; *)
 M0 (OUT, IN, VS, VS);
pe3 #(.w(2e-06), .l(3e-07), .as(9.6e-13), .ad(9.6e-13), .ps(4.96e-06), .pd(4.96e-06), .nrs(0.135), .nrd(0.135), .m((1)*(1)), .par1((1)*(1)))
(* integer passed_mfactor = "m"; *)
 M1 (OUT, IN, VD, VD);

endmodule
// Library - INV_HV, Cell - inv_hv, View - schematic
// LAST TIME SAVED: Feb  5 02:38:24 2024
// NETLIST TIME: Feb  9 05:16:35 2024

`worklib INV_HV
`view schematic

`timescale 1ns / 1ps
(* cds_ams_schematic *)

module inv_hv (GNDHV, IN, OUT, VDDHV, VSUB);
inout  GNDHV, IN, OUT, VDDHV, VSUB;
nedia #(.w(4e-05), .l(1.25e-06), .m((1)*(1)), .par1((1)*(1)), .extlay(0), .xf_subext(0))
(* integer passed_mfactor = "m"; *)
 M0 (OUT, IN, GNDHV, VSUB);
rpp1k1_3 #(.l(0.000103425), .w(1e-05), .m(1), .par1(1))
(* integer passed_mfactor = "m"; *)
 R0 (VDDHV, OUT, VSUB);

endmodule
// Library - TOP, Cell - top, View - schematic
// LAST TIME SAVED: Feb  7 07:37:55 2024
// NETLIST TIME: Feb  9 05:16:35 2024

`worklib TOP
`view schematic

`timescale 1ns / 1ps
(* cds_ams_schematic *)

module top (CLK, ENABLE, GNDA, GNDD, GNDHV, GNDOHV, GNDOR, GNDORA, INL, OUT0, OUT1, OUT2, OUTHV, OUTL, PSUB, RESET, VDDA, VDDD, VDDHV, VDDOR, VDDORA);
inout  CLK, ENABLE, GNDA, GNDD, GNDHV, GNDOHV, GNDOR, GNDORA, INL, OUT0, OUT1, OUT2, OUTHV, OUTL, PSUB, RESET, VDDA, VDDD, VDDHV, VDDOR, VDDORA;
wire [7:0] out;
wire clk;
wire enable;
wire reset;
ioring I0 (.GNDA( GNDA ), .GNDD( GNDD ), .GNDHV( GNDHV ), .GNDOHV( GNDOHV ), .GNDOR( GNDOR ), .GNDORA( GNDORA ), .VDDA( VDDA ), .VDDD( VDDD ), .VDDHV( VDDHV ), .VDDOR( VDDOR ), .VDDORA( VDDORA ), .reset_core( reset ), .out2_core( out[2] ), .out1_core( out[1] ), .out0_core( out[0] ), .inl_core( INL ), .enable_core( enable ), .clk_core( clk ), .ENABLE( ENABLE ), .CLK( CLK ), .RESET( RESET ), .PSUB( PSUB ), .OUTL( OUTL ), .OUTHV( OUTHV ), .OUT2( OUT2 ), .OUT1( OUT1 ), .OUT0( OUT0 ), .INL( INL ));
inv I1 (.VS( GNDA ), .VD( VDDA ), .OUT( OUTL ), .IN( INL ));
inv_hv I2 (.GNDHV( GNDHV ), .VSUB( PSUB ), .VDDHV( VDDHV ), .OUT( OUTHV ), .IN( out[2] ));
counter (*  integer cds_net_set [0:1] = { "power_vdd3i","ground_gnd3i" }; integer power_vdd3i = "VDDD"; integer ground_gnd3i = "GNDD";  *)  I3 (.out( out ), .reset( reset ), .clk( clk ), .enable( enable ));

endmodule
// Library - TOP, Cell - top_tb, View - schematic
// LAST TIME SAVED: Feb  9 05:01:40 2024
// NETLIST TIME: Feb  9 05:16:35 2024

`worklib TOP
`view schematic

`timescale 1ns / 1ps
(* cds_ams_schematic *)

module top_tb ( );
wire clk;
wire enable;
wire in_l;
wire reset;
wire out0;
wire out1;
wire out2;
wire out_h;
wire out_l;
wire VDDHV;
wire VDDD;
wire VDDA;
wire net7;
wire net12;
wire net8;
wire net15;
wire net17;
wire net9;
wire net13;
top I0 (.GNDA( net13 ), .GNDD( net9 ), .GNDHV( net17 ), .GNDOHV( net15 ), .GNDOR( net8 ), .GNDORA( net12 ), .PSUB( net7 ), .VDDA( VDDA ), .VDDD( VDDD ), .VDDHV( VDDHV ), .VDDOR( VDDD ), .VDDORA( VDDA ), .OUTL( out_l ), .OUTHV( out_h ), .OUT2( out2 ), .OUT1( out1 ), .OUT0( out0 ), .RESET( reset ), .INL( in_l ), .ENABLE( enable ), .CLK( clk ));
counter_stimulus I1 (.clk( clk ), .enable( enable ), .reset( reset ));
vsource #(.dc(0), .type("dc")) V9 (net16, cds_globals.\gnd! );
vsource #(.dc(0), .type("dc")) V8 (net14, cds_globals.\gnd! );
vsource #(.dc(0), .type("dc")) V7 (net11, cds_globals.\gnd! );
vsource #(.dc(0), .type("dc")) V6 (net10, cds_globals.\gnd! );
vsource #(.dc(0), .type("dc")) V5 (net6, cds_globals.\gnd! );
vsource #(.dc(0), .type("dc")) V4 (net5, cds_globals.\gnd! );
vsource #(.dc(0), .type("dc")) V3 (net4, cds_globals.\gnd! );
vsource #(.dc(40), .type("dc")) V2 (net3, cds_globals.\gnd! );
vsource #(.dc(3.3), .type("dc")) V1 (net2, cds_globals.\gnd! );
vsource #(.dc(3.3), .type("dc")) V0 (net1, cds_globals.\gnd! );
resistor #(.r(0.1)) R9 (net17, net16);
resistor #(.r(0.1)) R8 (net15, net14);
resistor #(.r(0.1)) R7 (net13, net11);
resistor #(.r(0.1)) R6 (net12, net10);
resistor #(.r(0.1)) R5 (net9, net6);
resistor #(.r(0.1)) R4 (net8, net5);
resistor #(.r(0.1)) R3 (net7, net4);
resistor #(.r(0.1)) R2 (VDDHV, net3);
resistor #(.r(0.1)) R1 (VDDA, net2);
resistor #(.r(0.1)) R0 (VDDD, net1);
vsource #(.type("pulse"), .val0(0), .val1(3.3), .period(1e-07), .delay(1e-08), .rise(1e-09), .fall(1e-09), .width(5e-08)) V10 (in_l, cds_globals.\gnd! );

endmodule
`noworklib
`noview
