// Design: CHARACTERIZATION/FT
simulator lang=spectre
global 0
parameters temperature=27 WF=10e-6 VDS=0.5 NF=2 L=180e-9 IDS=63.09573445u
include "/home/saul/pkg/xfab/XKIT/xh018/cadence/v9_0/spectre/v9_0_2/lpmos/config.scs" section=default
include "/home/saul/pkg/xfab/XKIT/xh018/cadence/v9_0/spectre/v9_0_2/lpmos/param.scs" section=3s
include "/home/saul/pkg/xfab/XKIT/xh018/cadence/v9_0/spectre/v9_0_2/lpmos/bip.scs" section=tm
include "/home/saul/pkg/xfab/XKIT/xh018/cadence/v9_0/spectre/v9_0_2/lpmos/cap.scs" section=tm
include "/home/saul/pkg/xfab/XKIT/xh018/cadence/v9_0/spectre/v9_0_2/lpmos/dio.scs" section=tm
include "/home/saul/pkg/xfab/XKIT/xh018/cadence/v9_0/spectre/v9_0_2/lpmos/mos.scs" section=tm
include "/home/saul/pkg/xfab/XKIT/xh018/cadence/v9_0/spectre/v9_0_2/lpmos/photo.scs" section=tm
include "/home/saul/pkg/xfab/XKIT/xh018/cadence/v9_0/spectre/v9_0_2/lpmos/res.scs" section=tm

// CHARACTERIZATION/FT/schematic
V1 (net10 0) vsource dc=VDS type=dc
I0 (0 D) isource dc=IDS type=dc
E0 (net11 0 net5 net10) vcvs gain=1000
R1 (G net11) resistor r=10M
R0 (D net5) resistor r=10M
C1 (net7 D) capacitor c=1
C0 (net5 0) capacitor c=1
IPRB0 (0 net7) iprobe
I3 (0 G) isource mag=1 type=sine
M0 (D G 0 0) nel w=WF l=L m=(1)*(NF)
simulatorOptions options temp=27
ac ac start=1 stop=100G dec=10
save IPRB0:in
