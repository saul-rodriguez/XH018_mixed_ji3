// Design: CHARACTERIZATION/DC_BIAS_NMOS_HV
simulator lang=spectre
global 0
parameters temperature=27 VGS=11.5 VDS=1 NF=4 WF=0.0001
include "/home/saul/pkg/xfab/XKIT/xh018/cadence/v9_0/spectre/v9_0_2/lpmos/config.scs" section=default
include "/home/saul/pkg/xfab/XKIT/xh018/cadence/v9_0/spectre/v9_0_2/lpmos/param.scs" section=3s
include "/home/saul/pkg/xfab/XKIT/xh018/cadence/v9_0/spectre/v9_0_2/lpmos/bip.scs" section=tm
include "/home/saul/pkg/xfab/XKIT/xh018/cadence/v9_0/spectre/v9_0_2/lpmos/cap.scs" section=tm
include "/home/saul/pkg/xfab/XKIT/xh018/cadence/v9_0/spectre/v9_0_2/lpmos/dio.scs" section=tm
include "/home/saul/pkg/xfab/XKIT/xh018/cadence/v9_0/spectre/v9_0_2/lpmos/mos.scs" section=tm
include "/home/saul/pkg/xfab/XKIT/xh018/cadence/v9_0/spectre/v9_0_2/lpmos/photo.scs" section=tm
include "/home/saul/pkg/xfab/XKIT/xh018/cadence/v9_0/spectre/v9_0_2/lpmos/res.scs" section=tm

// CHARACTERIZATION/DC_BIAS_NMOS_HV/schematic
V1 (net3 0) vsource dc=VDS type=dc
V0 (net2 0) vsource dc=VGS type=dc
M0 (net3 net2 0 0) nedia w=WF l=1.25u m=(1)*(NF) par1=(1)*(NF) extlay=0 xf_subext=0
simulatorOptions options temp=27
dc dc param=VDS start=0 stop=45 step=0.5
save M0:1
