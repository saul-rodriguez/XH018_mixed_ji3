// Design: CHARACTERIZATION/DC_BIAS_NMOS_3
simulator lang=spectre
global 0
parameters temperature=27 L1=1u NF1=1 VDS=0.0:0.05:1.8 VGS=0 WF1=10u
include "/home/saul/pkg/xfab/XKIT/xh018/cadence/v9_0/spectre/v9_0_2/lpmos/config.scs" section=default
include "/home/saul/pkg/xfab/XKIT/xh018/cadence/v9_0/spectre/v9_0_2/lpmos/param.scs" section=3s
include "/home/saul/pkg/xfab/XKIT/xh018/cadence/v9_0/spectre/v9_0_2/lpmos/bip.scs" section=tm
include "/home/saul/pkg/xfab/XKIT/xh018/cadence/v9_0/spectre/v9_0_2/lpmos/cap.scs" section=tm
include "/home/saul/pkg/xfab/XKIT/xh018/cadence/v9_0/spectre/v9_0_2/lpmos/dio.scs" section=tm
include "/home/saul/pkg/xfab/XKIT/xh018/cadence/v9_0/spectre/v9_0_2/lpmos/mos.scs" section=tm
include "/home/saul/pkg/xfab/XKIT/xh018/cadence/v9_0/spectre/v9_0_2/lpmos/photo.scs" section=tm
include "/home/saul/pkg/xfab/XKIT/xh018/cadence/v9_0/spectre/v9_0_2/lpmos/res.scs" section=tm

// CHARACTERIZATION/DC_BIAS_NMOS_3/schematic
M0 (net3 net2 0 0) ne3 w=WF1 l=L1 m=(1)*(NF1)
V1 (net3 0) vsource dc=VDS type=dc
V0 (net2 0) vsource dc=VGS type=dc
simulatorOptions options temp=27
dc dc param=VGS start=0 stop=1.8 step=0.05
save M0:1
