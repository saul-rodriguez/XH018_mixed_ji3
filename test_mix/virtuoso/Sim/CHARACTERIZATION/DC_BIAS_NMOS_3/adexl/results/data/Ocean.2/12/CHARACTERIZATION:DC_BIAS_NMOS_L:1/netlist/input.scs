// Design: CHARACTERIZATION/DC_BIAS_NMOS_3
simulator lang=spectre
global 0
parameters temperature=27 WF=10e-6 VGS=0.55 VDS=1 NF=1 L=180e-9
include "/home/saul/pkg/xfab/XKIT/xh018/cadence/v9_0/spectre/v9_0_2/lpmos/config.scs" section=default
include "/home/saul/pkg/xfab/XKIT/xh018/cadence/v9_0/spectre/v9_0_2/lpmos/param.scs" section=3s
include "/home/saul/pkg/xfab/XKIT/xh018/cadence/v9_0/spectre/v9_0_2/lpmos/bip.scs" section=tm
include "/home/saul/pkg/xfab/XKIT/xh018/cadence/v9_0/spectre/v9_0_2/lpmos/cap.scs" section=tm
include "/home/saul/pkg/xfab/XKIT/xh018/cadence/v9_0/spectre/v9_0_2/lpmos/dio.scs" section=tm
include "/home/saul/pkg/xfab/XKIT/xh018/cadence/v9_0/spectre/v9_0_2/lpmos/mos.scs" section=tm
include "/home/saul/pkg/xfab/XKIT/xh018/cadence/v9_0/spectre/v9_0_2/lpmos/photo.scs" section=tm
include "/home/saul/pkg/xfab/XKIT/xh018/cadence/v9_0/spectre/v9_0_2/lpmos/res.scs" section=tm

// CHARACTERIZATION/DC_BIAS_NMOS_3/schematic
M0 (net3 net2 0 0) ne3 w=WF l=L m=(1)*(NF)
V1 (net3 0) vsource dc=VDS type=dc
V0 (net2 0) vsource dc=VGS type=dc
simulatorOptions options temp=27
dc dc param=VDS start=0 stop=3.3 step=0.05
save M0:1
