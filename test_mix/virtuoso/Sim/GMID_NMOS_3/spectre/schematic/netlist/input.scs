// Design: CHARACTERIZATION/GMID_NMOS_3
simulator lang=spectre
global 0
parameters IDS1=1e-06 VDS1=0.5 WF1=1e-05 L1=1e-06 NF1=10
include "/home/saul/pkg/xfab/XKIT/xh018/cadence/v9_0/spectre/v9_0_2/lpmos/config.scs" section=default
include "/home/saul/pkg/xfab/XKIT/xh018/cadence/v9_0/spectre/v9_0_2/lpmos/param.scs" section=3s
include "/home/saul/pkg/xfab/XKIT/xh018/cadence/v9_0/spectre/v9_0_2/lpmos/bip.scs" section=tm
include "/home/saul/pkg/xfab/XKIT/xh018/cadence/v9_0/spectre/v9_0_2/lpmos/cap.scs" section=tm
include "/home/saul/pkg/xfab/XKIT/xh018/cadence/v9_0/spectre/v9_0_2/lpmos/dio.scs" section=tm
include "/home/saul/pkg/xfab/XKIT/xh018/cadence/v9_0/spectre/v9_0_2/lpmos/mos.scs" section=tm
include "/home/saul/pkg/xfab/XKIT/xh018/cadence/v9_0/spectre/v9_0_2/lpmos/photo.scs" section=tm
include "/home/saul/pkg/xfab/XKIT/xh018/cadence/v9_0/spectre/v9_0_2/lpmos/res.scs" section=tm

// CHARACTERIZATION/BIAS_NMOS_3/schematic
subckt BIAS_NMOS_3
parameters IDS VDS WF L NF
    I0 (0 D) isource dc=IDS type=dc
    V1 (net6 0) vsource dc=VDS type=dc
    E0 (G 0 D net6) vcvs gain=1000
    M0 (D G 0 0) ne3 w=WF l=L m=(1)*(NF)
ends BIAS_NMOS_3

// CHARACTERIZATION/GMID_NMOS_3/schematic
I0 BIAS_NMOS_3 IDS=IDS1 VDS=VDS1 WF=WF1 L=L1 NF=NF1
simulatorOptions options temp=27
dcOp dc
dc dc param=IDS1 start=10n stop=2m dec=20
save I0.M0.m1:gm I0.M0:gm I0.M0.m1:id I0.M0:id
