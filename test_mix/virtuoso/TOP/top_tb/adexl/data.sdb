ADE simulation setup
Run mode: Single Run, Sweeps and Corners
Tests:
  TOP:top_tb:1: TOP/top_tb/config, simulator ams
