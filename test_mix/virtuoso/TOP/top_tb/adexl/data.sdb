ADE simulation setup
Run mode: Single Run, Sweeps and Corners
Tests:
  TOP:top_tb:1 (off): TOP/top_tb/config_functional, simulator ams
  TOP:top_tb:1:1: TOP/top_tb/config_sch, simulator ams
